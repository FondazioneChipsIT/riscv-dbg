* NGSPICE file created from RVDBG4614.ext - technology: ihp-sg13g2

* Black-box entry subcircuit for sg13g2_decap_8 abstract view
.subckt sg13g2_decap_8 VDD VSS
.ends

* Black-box entry subcircuit for sg13g2_fill_1 abstract view
.subckt sg13g2_fill_1 VDD VSS
.ends

* Black-box entry subcircuit for sg13g2_nand3_1 abstract view
.subckt sg13g2_nand3_1 Y A B C VDD VSS
.ends

* Black-box entry subcircuit for sg13g2_decap_4 abstract view
.subckt sg13g2_decap_4 VDD VSS
.ends

* Black-box entry subcircuit for sg13g2_dfrbpq_1 abstract view
.subckt sg13g2_dfrbpq_1 Q CLK D RESET_B VDD VSS
.ends

* Black-box entry subcircuit for sg13g2_nor2b_1 abstract view
.subckt sg13g2_nor2b_1 Y A B_N VDD VSS
.ends

* Black-box entry subcircuit for sg13g2_mux2_1 abstract view
.subckt sg13g2_mux2_1 X A0 A1 S VDD VSS
.ends

* Black-box entry subcircuit for sg13g2_nand4_1 abstract view
.subckt sg13g2_nand4_1 Y A B C D VDD VSS
.ends

* Black-box entry subcircuit for sg13g2_nand2_1 abstract view
.subckt sg13g2_nand2_1 Y A B VDD VSS
.ends

* Black-box entry subcircuit for sg13g2_a22oi_1 abstract view
.subckt sg13g2_a22oi_1 Y A1 A2 B1 B2 VDD VSS
.ends

* Black-box entry subcircuit for sg13g2_fill_2 abstract view
.subckt sg13g2_fill_2 VDD VSS
.ends

* Black-box entry subcircuit for sg13g2_nor3_1 abstract view
.subckt sg13g2_nor3_1 Y A B C VDD VSS
.ends

* Black-box entry subcircuit for sg13g2_o21ai_1 abstract view
.subckt sg13g2_o21ai_1 Y A1 A2 B1 VDD VSS
.ends

* Black-box entry subcircuit for sg13g2_a21oi_1 abstract view
.subckt sg13g2_a21oi_1 Y A1 A2 B1 VDD VSS
.ends

* Black-box entry subcircuit for sg13g2_nor4_1 abstract view
.subckt sg13g2_nor4_1 Y A B C D VDD VSS
.ends

* Black-box entry subcircuit for sg13g2_inv_1 abstract view
.subckt sg13g2_inv_1 Y A VDD VSS
.ends

* Black-box entry subcircuit for sg13g2_buf_1 abstract view
.subckt sg13g2_buf_1 X A VDD VSS
.ends

* Black-box entry subcircuit for sg13g2_a221oi_1 abstract view
.subckt sg13g2_a221oi_1 Y A1 A2 B1 B2 C1 VDD VSS
.ends

* Black-box entry subcircuit for sg13g2_nor2_1 abstract view
.subckt sg13g2_nor2_1 Y A B VDD VSS
.ends

* Black-box entry subcircuit for sg13g2_and3_1 abstract view
.subckt sg13g2_and3_1 X A B C VDD VSS
.ends

* Black-box entry subcircuit for sg13g2_dlygate4sd3_1 abstract view
.subckt sg13g2_dlygate4sd3_1 X A VDD VSS
.ends

* Black-box entry subcircuit for sg13g2_nand3b_1 abstract view
.subckt sg13g2_nand3b_1 Y A_N B C VDD VSS
.ends

* Black-box entry subcircuit for sg13g2_mux4_1 abstract view
.subckt sg13g2_mux4_1 X A0 A1 A2 A3 S0 S1 VDD VSS
.ends

* Black-box entry subcircuit for sg13g2_and4_1 abstract view
.subckt sg13g2_and4_1 X A B C D VDD VSS
.ends

* Black-box entry subcircuit for sg13g2_and2_1 abstract view
.subckt sg13g2_and2_1 X A B VDD VSS
.ends

* Black-box entry subcircuit for sg13g2_xnor2_1 abstract view
.subckt sg13g2_xnor2_1 Y A B VDD VSS
.ends

* Black-box entry subcircuit for sg13g2_nand2b_1 abstract view
.subckt sg13g2_nand2b_1 Y A_N B VDD VSS
.ends

* Black-box entry subcircuit for sg13g2_tiehi abstract view
.subckt sg13g2_tiehi L_HI VDD VSS
.ends

* Black-box entry subcircuit for sg13g2_a21o_1 abstract view
.subckt sg13g2_a21o_1 X A1 A2 B1 VDD VSS
.ends

* Black-box entry subcircuit for sg13g2_or4_1 abstract view
.subckt sg13g2_or4_1 X A B C D VDD VSS
.ends

* Black-box entry subcircuit for sg13g2_buf_8 abstract view
.subckt sg13g2_buf_8 X A VDD VSS
.ends

* Black-box entry subcircuit for sg13g2_or3_1 abstract view
.subckt sg13g2_or3_1 X A B C VDD VSS
.ends

* Black-box entry subcircuit for sg13g2_xor2_1 abstract view
.subckt sg13g2_xor2_1 X A B VDD VSS
.ends

* Black-box entry subcircuit for sg13g2_or2_1 abstract view
.subckt sg13g2_or2_1 X A B VDD VSS
.ends

* Black-box entry subcircuit for sg13g2_buf_16 abstract view
.subckt sg13g2_buf_16 X A VDD VSS
.ends

* Black-box entry subcircuit for sg13g2_inv_4 abstract view
.subckt sg13g2_inv_4 Y A VDD VSS
.ends

* Black-box entry subcircuit for sg13g2_inv_8 abstract view
.subckt sg13g2_inv_8 Y A VDD VSS
.ends

* Black-box entry subcircuit for sg13g2_inv_2 abstract view
.subckt sg13g2_inv_2 Y A VDD VSS
.ends

* Black-box entry subcircuit for sg13g2_inv_16 abstract view
.subckt sg13g2_inv_16 Y A VDD VSS
.ends

* Black-box entry subcircuit for sg13g2_antennanp abstract view
.subckt sg13g2_antennanp A VDD VSS
.ends

.subckt RVDBG4614 VGND VPWR clk_i debug_req_o dmactive_o hartinfo_i[0] hartinfo_i[10]
+ hartinfo_i[11] hartinfo_i[12] hartinfo_i[13] hartinfo_i[14] hartinfo_i[15] hartinfo_i[16]
+ hartinfo_i[17] hartinfo_i[18] hartinfo_i[19] hartinfo_i[1] hartinfo_i[20] hartinfo_i[21]
+ hartinfo_i[22] hartinfo_i[23] hartinfo_i[24] hartinfo_i[25] hartinfo_i[26] hartinfo_i[27]
+ hartinfo_i[28] hartinfo_i[29] hartinfo_i[2] hartinfo_i[30] hartinfo_i[31] hartinfo_i[3]
+ hartinfo_i[4] hartinfo_i[5] hartinfo_i[6] hartinfo_i[7] hartinfo_i[8] hartinfo_i[9]
+ jtag_tck_i jtag_tdi_i jtag_tdo_o jtag_tdo_oe_o jtag_tms_i jtag_trst_ni master_addr_o[0]
+ master_addr_o[10] master_addr_o[11] master_addr_o[12] master_addr_o[13] master_addr_o[14]
+ master_addr_o[15] master_addr_o[16] master_addr_o[17] master_addr_o[18] master_addr_o[19]
+ master_addr_o[1] master_addr_o[20] master_addr_o[21] master_addr_o[22] master_addr_o[23]
+ master_addr_o[24] master_addr_o[25] master_addr_o[26] master_addr_o[27] master_addr_o[28]
+ master_addr_o[29] master_addr_o[2] master_addr_o[30] master_addr_o[31] master_addr_o[3]
+ master_addr_o[4] master_addr_o[5] master_addr_o[6] master_addr_o[7] master_addr_o[8]
+ master_addr_o[9] master_be_o[0] master_be_o[1] master_be_o[2] master_be_o[3] master_err_i
+ master_gnt_i master_other_err_i master_rdata_i[0] master_rdata_i[10] master_rdata_i[11]
+ master_rdata_i[12] master_rdata_i[13] master_rdata_i[14] master_rdata_i[15] master_rdata_i[16]
+ master_rdata_i[17] master_rdata_i[18] master_rdata_i[19] master_rdata_i[1] master_rdata_i[20]
+ master_rdata_i[21] master_rdata_i[22] master_rdata_i[23] master_rdata_i[24] master_rdata_i[25]
+ master_rdata_i[26] master_rdata_i[27] master_rdata_i[28] master_rdata_i[29] master_rdata_i[2]
+ master_rdata_i[30] master_rdata_i[31] master_rdata_i[3] master_rdata_i[4] master_rdata_i[5]
+ master_rdata_i[6] master_rdata_i[7] master_rdata_i[8] master_rdata_i[9] master_req_o
+ master_rvalid_i master_wdata_o[0] master_wdata_o[10] master_wdata_o[11] master_wdata_o[12]
+ master_wdata_o[13] master_wdata_o[14] master_wdata_o[15] master_wdata_o[16] master_wdata_o[17]
+ master_wdata_o[18] master_wdata_o[19] master_wdata_o[1] master_wdata_o[20] master_wdata_o[21]
+ master_wdata_o[22] master_wdata_o[23] master_wdata_o[24] master_wdata_o[25] master_wdata_o[26]
+ master_wdata_o[27] master_wdata_o[28] master_wdata_o[29] master_wdata_o[2] master_wdata_o[30]
+ master_wdata_o[31] master_wdata_o[3] master_wdata_o[4] master_wdata_o[5] master_wdata_o[6]
+ master_wdata_o[7] master_wdata_o[8] master_wdata_o[9] master_we_o ndmreset_o rst_ni
+ slave_addr_i[0] slave_addr_i[10] slave_addr_i[11] slave_addr_i[12] slave_addr_i[13]
+ slave_addr_i[14] slave_addr_i[15] slave_addr_i[16] slave_addr_i[17] slave_addr_i[18]
+ slave_addr_i[19] slave_addr_i[1] slave_addr_i[20] slave_addr_i[21] slave_addr_i[22]
+ slave_addr_i[23] slave_addr_i[24] slave_addr_i[25] slave_addr_i[26] slave_addr_i[27]
+ slave_addr_i[28] slave_addr_i[29] slave_addr_i[2] slave_addr_i[30] slave_addr_i[31]
+ slave_addr_i[3] slave_addr_i[4] slave_addr_i[5] slave_addr_i[6] slave_addr_i[7]
+ slave_addr_i[8] slave_addr_i[9] slave_aid_i[0] slave_aid_i[1] slave_aid_i[2] slave_aid_i[3]
+ slave_be_i[0] slave_be_i[1] slave_be_i[2] slave_be_i[3] slave_gnt_o slave_rdata_o[0]
+ slave_rdata_o[10] slave_rdata_o[11] slave_rdata_o[12] slave_rdata_o[13] slave_rdata_o[14]
+ slave_rdata_o[15] slave_rdata_o[16] slave_rdata_o[17] slave_rdata_o[18] slave_rdata_o[19]
+ slave_rdata_o[1] slave_rdata_o[20] slave_rdata_o[21] slave_rdata_o[22] slave_rdata_o[23]
+ slave_rdata_o[24] slave_rdata_o[25] slave_rdata_o[26] slave_rdata_o[27] slave_rdata_o[28]
+ slave_rdata_o[29] slave_rdata_o[2] slave_rdata_o[30] slave_rdata_o[31] slave_rdata_o[3]
+ slave_rdata_o[4] slave_rdata_o[5] slave_rdata_o[6] slave_rdata_o[7] slave_rdata_o[8]
+ slave_rdata_o[9] slave_req_i slave_rid_o[0] slave_rid_o[1] slave_rid_o[2] slave_rid_o[3]
+ slave_rvalid_o slave_wdata_i[0] slave_wdata_i[10] slave_wdata_i[11] slave_wdata_i[12]
+ slave_wdata_i[13] slave_wdata_i[14] slave_wdata_i[15] slave_wdata_i[16] slave_wdata_i[17]
+ slave_wdata_i[18] slave_wdata_i[19] slave_wdata_i[1] slave_wdata_i[20] slave_wdata_i[21]
+ slave_wdata_i[22] slave_wdata_i[23] slave_wdata_i[24] slave_wdata_i[25] slave_wdata_i[26]
+ slave_wdata_i[27] slave_wdata_i[28] slave_wdata_i[29] slave_wdata_i[2] slave_wdata_i[30]
+ slave_wdata_i[31] slave_wdata_i[3] slave_wdata_i[4] slave_wdata_i[5] slave_wdata_i[6]
+ slave_wdata_i[7] slave_wdata_i[8] slave_wdata_i[9] slave_we_i testmode_i unavailable_i
XFILLER_67_520 VPWR VGND sg13g2_decap_8
XFILLER_94_361 VPWR VGND sg13g2_fill_1
XFILLER_67_575 VPWR VGND sg13g2_decap_8
X_7963_ _7963_/Y _7979_/A _8992_/Q _8353_/C VPWR VGND sg13g2_nand3_1
XFILLER_54_269 VPWR VGND sg13g2_decap_4
X_9702_ _9702_/Q _9708_/CLK _9702_/D fanout953/X VPWR VGND sg13g2_dfrbpq_1
X_6914_ _6915_/B _9708_/Q _6939_/B VPWR VGND sg13g2_nor2b_1
X_7894_ _7894_/Y _7904_/A _8962_/Q _8361_/C VPWR VGND sg13g2_nand3_1
X_6845_ _6845_/X _8896_/Q _8928_/Q _6877_/S VPWR VGND sg13g2_mux2_1
XFILLER_62_291 VPWR VGND sg13g2_decap_8
X_9633_ _9633_/Q _9686_/CLK _9633_/D fanout969/X VPWR VGND sg13g2_dfrbpq_1
X_6776_ _9535_/D _9535_/Q _9445_/Q _6779_/S VPWR VGND sg13g2_mux2_1
X_9564_ _9564_/Q _9567_/CLK _9564_/D _9564_/RESET_B VPWR VGND sg13g2_dfrbpq_1
X_9495_ _9495_/Q _9603_/CLK _9495_/D _9495_/RESET_B VPWR VGND sg13g2_dfrbpq_1
X_8515_ _8536_/B _8515_/A _8515_/B _8515_/C _8515_/D VPWR VGND sg13g2_nand4_1
X_5727_ _5727_/Y _5736_/A _9317_/Q VPWR VGND sg13g2_nand2_1
XFILLER_109_728 VPWR VGND sg13g2_decap_8
X_8446_ _8446_/Y _8488_/A _8446_/B _8492_/C VPWR VGND sg13g2_nand3_1
X_5658_ _5658_/Y _5658_/A _8611_/Q VPWR VGND sg13g2_nand2_1
X_5589_ _5589_/Y _9449_/Q _5591_/B _5589_/B1 _8651_/Q VPWR VGND sg13g2_a22oi_1
X_4609_ _8520_/C _6519_/B _6534_/C VPWR VGND sg13g2_nand2_1
XFILLER_2_505 VPWR VGND sg13g2_fill_2
X_8377_ _8377_/Y _8409_/A _9189_/Q _8409_/C VPWR VGND sg13g2_nand3_1
XFILLER_116_271 VPWR VGND sg13g2_decap_8
X_7328_ _7330_/B _7351_/C _9118_/Q _7387_/C VPWR VGND sg13g2_nor3_1
XFILLER_7_7 VPWR VGND sg13g2_decap_8
XFILLER_77_37 VPWR VGND sg13g2_fill_2
X_7259_ _7259_/Y _7253_/Y _7258_/Y _7512_/B1 VPWR VGND sg13g2_o21ai_1
XFILLER_104_499 VPWR VGND sg13g2_decap_8
XFILLER_89_199 VPWR VGND sg13g2_decap_8
XFILLER_85_383 VPWR VGND sg13g2_fill_2
XFILLER_46_748 VPWR VGND sg13g2_decap_8
XFILLER_73_556 VPWR VGND sg13g2_decap_8
XFILLER_60_239 VPWR VGND sg13g2_decap_8
XFILLER_41_420 VPWR VGND sg13g2_fill_2
XFILLER_13_144 VPWR VGND sg13g2_decap_8
XFILLER_42_84 VPWR VGND sg13g2_decap_8
XFILLER_107_282 VPWR VGND sg13g2_fill_2
XFILLER_123_775 VPWR VGND sg13g2_decap_8
XFILLER_3_56 VPWR VGND sg13g2_decap_4
XFILLER_110_425 VPWR VGND sg13g2_fill_1
XFILLER_37_726 VPWR VGND sg13g2_decap_8
XFILLER_37_748 VPWR VGND sg13g2_decap_4
XFILLER_91_364 VPWR VGND sg13g2_decap_8
X_4960_ _4960_/Y _4960_/A _5020_/B _4960_/C _4960_/D VPWR VGND sg13g2_nand4_1
XFILLER_45_770 VPWR VGND sg13g2_fill_1
XFILLER_60_751 VPWR VGND sg13g2_fill_2
X_4891_ _4891_/Y _9389_/Q _4891_/A2 _4890_/Y _4860_/Y VPWR VGND sg13g2_a22oi_1
X_6630_ _9440_/D _6653_/A1 _6629_/Y _6628_/Y VPWR VGND sg13g2_o21ai_1
XFILLER_20_615 VPWR VGND sg13g2_decap_8
X_6561_ _6562_/A _6951_/B _6561_/B _6803_/B VPWR VGND sg13g2_nor3_1
X_5512_ _8625_/D _5511_/Y _5510_/Y _5602_/B1 VPWR VGND sg13g2_a21oi_1
X_8300_ _9150_/D _8314_/A1 _8034_/Y _8299_/Y VPWR VGND sg13g2_o21ai_1
X_9280_ _9280_/Q _9305_/CLK _9280_/D place2405/X VPWR VGND sg13g2_dfrbpq_1
XFILLER_66_0 VPWR VGND sg13g2_decap_4
X_6492_ _6492_/Y _9080_/Q _6506_/B1 _6507_/B1 _9142_/Q VPWR VGND sg13g2_a22oi_1
XFILLER_8_181 VPWR VGND sg13g2_fill_2
X_8231_ _8231_/Y _8231_/A _8251_/B VPWR VGND sg13g2_nand2_1
X_5443_ _5444_/A _5455_/A1 _8680_/Q _8681_/Q _5451_/B2 VPWR VGND sg13g2_a22oi_1
X_5374_ _8814_/D _5375_/A _5375_/B _5374_/C _5375_/D VPWR VGND sg13g2_nor4_1
X_8162_ _9081_/D _7017_/Y _7954_/Y _8161_/Y VPWR VGND sg13g2_o21ai_1
X_4325_ _4325_/Y _9880_/A VPWR VGND sg13g2_inv_1
X_7113_ _8857_/D _7112_/Y _8857_/Q _7131_/S VPWR VGND sg13g2_mux2_1
XFILLER_99_464 VPWR VGND sg13g2_fill_2
XFILLER_87_615 VPWR VGND sg13g2_decap_8
X_8093_ _9047_/D _5372_/D _8092_/Y _8091_/Y VPWR VGND sg13g2_o21ai_1
XFILLER_86_103 VPWR VGND sg13g2_decap_8
XFILLER_87_648 VPWR VGND sg13g2_fill_2
XFILLER_59_339 VPWR VGND sg13g2_decap_8
X_7044_ _7044_/Y _7059_/A _8835_/Q VPWR VGND sg13g2_nand2_1
XFILLER_82_320 VPWR VGND sg13g2_decap_8
XFILLER_28_726 VPWR VGND sg13g2_decap_8
X_8995_ _8995_/Q clkload5/A _8995_/D place2498/X VPWR VGND sg13g2_dfrbpq_1
XFILLER_27_236 VPWR VGND sg13g2_fill_2
X_7946_ _7946_/Y _7946_/A _7946_/B _8092_/A VPWR VGND sg13g2_nand3_1
XFILLER_70_537 VPWR VGND sg13g2_decap_8
X_7877_ _8950_/D _8950_/Q _7697_/Y _7881_/S VPWR VGND sg13g2_mux2_1
XFILLER_23_431 VPWR VGND sg13g2_fill_1
XFILLER_35_291 VPWR VGND sg13g2_fill_1
X_6828_ _9576_/D _9609_/Q _9576_/Q _6834_/S VPWR VGND sg13g2_mux2_1
X_9616_ _9616_/Q _9621_/CLK _9616_/D _9616_/RESET_B VPWR VGND sg13g2_dfrbpq_1
XFILLER_51_762 VPWR VGND sg13g2_decap_8
XFILLER_50_272 VPWR VGND sg13g2_decap_4
XFILLER_11_648 VPWR VGND sg13g2_fill_1
X_9547_ _9547_/Q _9672_/CLK _9547_/D place2441/X VPWR VGND sg13g2_dfrbpq_1
X_6759_ _9518_/D _9518_/Q _9428_/Q _6783_/S VPWR VGND sg13g2_mux2_1
X_9478_ _9478_/Q clkload6/A _9478_/D _9478_/RESET_B VPWR VGND sg13g2_dfrbpq_1
XFILLER_12_54 VPWR VGND sg13g2_decap_8
X_8429_ _9218_/D _5270_/Y _8430_/A _8428_/Y VPWR VGND sg13g2_o21ai_1
XFILLER_12_65 VPWR VGND sg13g2_fill_2
XFILLER_117_580 VPWR VGND sg13g2_fill_2
XFILLER_117_591 VPWR VGND sg13g2_decap_4
XFILLER_105_742 VPWR VGND sg13g2_fill_2
XFILLER_88_69 VPWR VGND sg13g2_fill_1
XFILLER_73_353 VPWR VGND sg13g2_fill_1
XFILLER_18_236 VPWR VGND sg13g2_fill_1
XFILLER_19_759 VPWR VGND sg13g2_fill_2
XFILLER_46_589 VPWR VGND sg13g2_decap_8
XFILLER_26_291 VPWR VGND sg13g2_decap_8
XFILLER_14_475 VPWR VGND sg13g2_decap_4
XFILLER_42_784 VPWR VGND sg13g2_fill_1
Xplace2509 _7187_/A _8817_/D VPWR VGND sg13g2_buf_1
XFILLER_10_670 VPWR VGND sg13g2_decap_4
Xplace1808 _8397_/A _8407_/A VPWR VGND sg13g2_buf_1
Xplace1819 _8225_/B _8219_/B VPWR VGND sg13g2_buf_1
X_5090_ _5090_/Y _5090_/A _5090_/B VPWR VGND sg13g2_nand2_1
XFILLER_69_637 VPWR VGND sg13g2_decap_4
XFILLER_84_629 VPWR VGND sg13g2_decap_8
XFILLER_110_299 VPWR VGND sg13g2_fill_1
XFILLER_110_277 VPWR VGND sg13g2_decap_8
XFILLER_92_662 VPWR VGND sg13g2_decap_8
X_5992_ _5992_/Y _5992_/A _6004_/B _6004_/C VPWR VGND sg13g2_nand3_1
X_8780_ _9886_/A _9260_/CLK _8780_/D place2392/X VPWR VGND sg13g2_dfrbpq_1
X_7800_ _7801_/D _9049_/Q _7782_/B _7799_/X VPWR VGND sg13g2_o21ai_1
XFILLER_18_770 VPWR VGND sg13g2_fill_2
XFILLER_37_589 VPWR VGND sg13g2_fill_1
X_7731_ _7733_/D _9269_/Q _5387_/B _7808_/B1 _8808_/Q VPWR VGND sg13g2_a22oi_1
XFILLER_52_548 VPWR VGND sg13g2_decap_4
X_4943_ _4943_/Y _5006_/A1 _4941_/Y _4942_/Y VPWR VGND sg13g2_o21ai_1
X_7662_ _7676_/A _9295_/Q _7843_/A2 _7843_/B1 _9327_/Q _7661_/Y VPWR VGND sg13g2_a221oi_1
X_6613_ _9435_/D _6656_/A1 _6612_/Y _6610_/Y VPWR VGND sg13g2_o21ai_1
X_4874_ _4874_/Y _4873_/X _4995_/S _4847_/Y VPWR VGND sg13g2_a21oi_1
XFILLER_33_784 VPWR VGND sg13g2_decap_4
X_9401_ _9401_/Q _9406_/CLK _9401_/D place2489/X VPWR VGND sg13g2_dfrbpq_1
X_7593_ _7595_/B _8517_/B _7551_/B _7808_/B1 _8801_/Q VPWR VGND sg13g2_a22oi_1
XFILLER_20_445 VPWR VGND sg13g2_decap_8
XFILLER_32_294 VPWR VGND sg13g2_fill_1
X_9332_ _9332_/Q _9409_/CLK _9332_/D place2399/X VPWR VGND sg13g2_dfrbpq_1
X_6544_ _6544_/Y _6544_/A _6558_/A VPWR VGND sg13g2_nor2_1
X_9263_ _9263_/Q _9305_/CLK _9263_/D place2405/X VPWR VGND sg13g2_dfrbpq_1
X_6475_ _6476_/A _6475_/A _6509_/B _6509_/C _6509_/D VPWR VGND sg13g2_nand4_1
X_8214_ _9107_/D _8222_/A1 _8086_/Y _8213_/Y VPWR VGND sg13g2_o21ai_1
X_5426_ _5427_/A _5439_/A1 _8667_/Q _5426_/B1 _5469_/B2 VPWR VGND sg13g2_a22oi_1
XFILLER_121_509 VPWR VGND sg13g2_fill_2
X_9194_ _9194_/Q clkload7/A _9194_/D place2458/X VPWR VGND sg13g2_dfrbpq_1
XFILLER_87_412 VPWR VGND sg13g2_fill_1
X_5357_ _8797_/D _5375_/A _5373_/B _5357_/C _5373_/D VPWR VGND sg13g2_nor4_1
X_8145_ _8145_/Y _9073_/Q _8161_/B VPWR VGND sg13g2_nand2_1
XFILLER_0_806 VPWR VGND sg13g2_fill_2
X_4308_ _6534_/C _9409_/Q VPWR VGND sg13g2_inv_1
X_5288_ _8775_/D _5288_/A1 _5367_/C _5287_/Y _5288_/B2 VPWR VGND sg13g2_a22oi_1
X_8076_ _8076_/Y _8076_/A _8101_/B VPWR VGND sg13g2_nand2_1
XFILLER_114_12 VPWR VGND sg13g2_decap_8
XFILLER_87_478 VPWR VGND sg13g2_decap_4
X_7027_ _8830_/D _8284_/A1 _7008_/Y _7026_/Y VPWR VGND sg13g2_o21ai_1
XFILLER_74_139 VPWR VGND sg13g2_decap_8
XFILLER_28_512 VPWR VGND sg13g2_decap_8
XFILLER_74_49 VPWR VGND sg13g2_fill_2
XFILLER_74_27 VPWR VGND sg13g2_decap_8
XFILLER_71_802 VPWR VGND sg13g2_fill_2
XFILLER_55_342 VPWR VGND sg13g2_decap_8
X_8978_ _8978_/Q _9199_/CLK _8978_/D place2410/X VPWR VGND sg13g2_dfrbpq_1
XFILLER_83_673 VPWR VGND sg13g2_fill_1
XFILLER_55_353 VPWR VGND sg13g2_fill_1
XFILLER_16_729 VPWR VGND sg13g2_decap_4
XFILLER_43_504 VPWR VGND sg13g2_decap_8
X_7929_ _8976_/D _5361_/C _7946_/A _7927_/Y VPWR VGND sg13g2_o21ai_1
XFILLER_82_172 VPWR VGND sg13g2_fill_2
XFILLER_24_751 VPWR VGND sg13g2_fill_1
XFILLER_23_42 VPWR VGND sg13g2_fill_2
XFILLER_23_294 VPWR VGND sg13g2_fill_1
XFILLER_7_416 VPWR VGND sg13g2_decap_8
XFILLER_99_46 VPWR VGND sg13g2_fill_1
XFILLER_99_68 VPWR VGND sg13g2_fill_2
XFILLER_3_644 VPWR VGND sg13g2_decap_8
XFILLER_3_666 VPWR VGND sg13g2_decap_8
XFILLER_2_143 VPWR VGND sg13g2_fill_2
XFILLER_78_434 VPWR VGND sg13g2_fill_2
XFILLER_59_681 VPWR VGND sg13g2_fill_1
XFILLER_58_191 VPWR VGND sg13g2_decap_8
XFILLER_0_35 VPWR VGND sg13g2_decap_8
XFILLER_46_342 VPWR VGND sg13g2_decap_8
XFILLER_19_589 VPWR VGND sg13g2_decap_4
XFILLER_64_93 VPWR VGND sg13g2_decap_8
XFILLER_61_367 VPWR VGND sg13g2_fill_1
XFILLER_61_356 VPWR VGND sg13g2_decap_8
XFILLER_61_389 VPWR VGND sg13g2_fill_2
XFILLER_14_261 VPWR VGND sg13g2_decap_8
XFILLER_119_119 VPWR VGND sg13g2_decap_8
XFILLER_80_70 VPWR VGND sg13g2_decap_8
X_4590_ _9696_/D _4590_/A _4590_/B _4590_/C VPWR VGND sg13g2_and3_1
XFILLER_30_776 VPWR VGND sg13g2_decap_4
XFILLER_30_798 VPWR VGND sg13g2_fill_2
Xplace2306 _5123_/B _9261_/Q VPWR VGND sg13g2_buf_1
Xplace2317 _6877_/S _9255_/Q VPWR VGND sg13g2_buf_1
Xplace2328 _4994_/A _5008_/A VPWR VGND sg13g2_buf_1
Xplace2339 _5891_/A1 _5930_/A1 VPWR VGND sg13g2_buf_1
X_6260_ _6264_/A _6260_/A _6438_/D _6271_/A VPWR VGND sg13g2_nand3_1
X_5211_ _5211_/Y _5215_/A _5223_/B _5274_/A1 VPWR VGND sg13g2_a21oi_1
Xhold3008 _8094_/A _9048_/Q VPWR VGND sg13g2_dlygate4sd3_1
Xhold3019 _6221_/B1 _9363_/Q VPWR VGND sg13g2_dlygate4sd3_1
X_6191_ _6191_/Y _8474_/B _6191_/B _6322_/B VPWR VGND sg13g2_nand3_1
XFILLER_97_754 VPWR VGND sg13g2_decap_4
XFILLER_97_732 VPWR VGND sg13g2_decap_8
X_5142_ _8756_/D _5080_/A _5139_/Y _5348_/C _5080_/Y VPWR VGND sg13g2_a22oi_1
XFILLER_97_776 VPWR VGND sg13g2_fill_2
X_5073_ _5080_/A _5073_/A _8515_/B _7482_/C _7519_/D VPWR VGND sg13g2_nand4_1
X_9881_ _9881_/X _9881_/A VPWR VGND sg13g2_buf_1
XFILLER_65_640 VPWR VGND sg13g2_decap_4
X_8901_ _8901_/Q _9198_/CLK _8901_/D place2452/X VPWR VGND sg13g2_dfrbpq_1
X_8832_ _8832_/Q _9504_/CLK _8832_/D place2430/X VPWR VGND sg13g2_dfrbpq_1
XFILLER_92_492 VPWR VGND sg13g2_decap_8
XFILLER_80_632 VPWR VGND sg13g2_fill_1
XFILLER_52_312 VPWR VGND sg13g2_fill_2
X_5975_ _5975_/Y _9327_/Q _5978_/B VPWR VGND sg13g2_nand2_1
X_8763_ _9869_/A _9252_/CLK _8763_/D place2400/X VPWR VGND sg13g2_dfrbpq_1
XFILLER_52_378 VPWR VGND sg13g2_fill_2
XFILLER_100_14 VPWR VGND sg13g2_decap_4
X_7714_ _7714_/Y _7714_/A _7714_/B _7714_/C _7714_/D VPWR VGND sg13g2_nand4_1
X_8694_ _8694_/Q _9630_/CLK _8694_/D fanout955/X VPWR VGND sg13g2_dfrbpq_1
X_4926_ _4926_/Y _5017_/A1 _4925_/Y _4909_/Y VPWR VGND sg13g2_o21ai_1
X_7645_ _7645_/Y _9072_/Q _7783_/B _7783_/C VPWR VGND sg13g2_nand3b_1
XFILLER_20_220 VPWR VGND sg13g2_fill_2
XFILLER_21_754 VPWR VGND sg13g2_fill_1
X_4857_ _4914_/B _4761_/X _4823_/B _4945_/A VPWR VGND sg13g2_a21oi_1
X_7576_ _8912_/D _8912_/Q _7575_/Y _7576_/S VPWR VGND sg13g2_mux2_1
XFILLER_21_787 VPWR VGND sg13g2_fill_1
X_9315_ _9315_/Q _9410_/CLK _9315_/D place2398/X VPWR VGND sg13g2_dfrbpq_1
X_6527_ _6528_/A _5378_/Y _6525_/X _6526_/X _6523_/A VPWR VGND sg13g2_a22oi_1
X_4788_ _4788_/Y _5000_/B1 _5012_/B _4787_/Y VPWR VGND sg13g2_o21ai_1
XFILLER_106_347 VPWR VGND sg13g2_fill_2
X_9246_ _9246_/Q _9251_/CLK _9246_/D place2481/X VPWR VGND sg13g2_dfrbpq_1
X_6458_ _9398_/D _6491_/A2 _6456_/Y _6457_/Y VPWR VGND sg13g2_a21oi_1
X_5409_ _5410_/B _9480_/Q _7010_/A _5412_/C VPWR VGND sg13g2_nand3_1
X_9177_ _9177_/Q _9242_/CLK _9177_/D place2494/X VPWR VGND sg13g2_dfrbpq_1
XFILLER_0_603 VPWR VGND sg13g2_fill_2
X_6389_ _6389_/X _9000_/Q _9062_/Q _9124_/Q _9186_/Q _6400_/S0 _6400_/S1 VPWR VGND
+ sg13g2_mux4_1
X_8128_ _9064_/D _7017_/Y _8053_/Y _8127_/Y VPWR VGND sg13g2_o21ai_1
XFILLER_102_597 VPWR VGND sg13g2_decap_4
X_8059_ _9035_/D _8100_/A1 _7920_/Y _8058_/Y VPWR VGND sg13g2_o21ai_1
XFILLER_83_470 VPWR VGND sg13g2_fill_2
XFILLER_28_375 VPWR VGND sg13g2_fill_1
XFILLER_71_632 VPWR VGND sg13g2_fill_1
XFILLER_16_548 VPWR VGND sg13g2_decap_4
XFILLER_70_131 VPWR VGND sg13g2_decap_8
XFILLER_31_518 VPWR VGND sg13g2_fill_1
XFILLER_34_85 VPWR VGND sg13g2_decap_8
XFILLER_11_253 VPWR VGND sg13g2_decap_8
XFILLER_7_213 VPWR VGND sg13g2_decap_8
XFILLER_7_202 VPWR VGND sg13g2_fill_2
XFILLER_50_40 VPWR VGND sg13g2_decap_8
XFILLER_109_174 VPWR VGND sg13g2_decap_4
XFILLER_98_529 VPWR VGND sg13g2_decap_8
XFILLER_98_507 VPWR VGND sg13g2_fill_2
XFILLER_3_441 VPWR VGND sg13g2_decap_8
XFILLER_3_485 VPWR VGND sg13g2_decap_8
XFILLER_79_765 VPWR VGND sg13g2_decap_4
XFILLER_22_7 VPWR VGND sg13g2_decap_4
XFILLER_39_618 VPWR VGND sg13g2_fill_1
XFILLER_94_746 VPWR VGND sg13g2_decap_8
XFILLER_94_713 VPWR VGND sg13g2_decap_8
XFILLER_78_275 VPWR VGND sg13g2_decap_8
XFILLER_66_437 VPWR VGND sg13g2_fill_2
XFILLER_39_629 VPWR VGND sg13g2_decap_4
XFILLER_19_331 VPWR VGND sg13g2_fill_1
XFILLER_19_342 VPWR VGND sg13g2_decap_8
XFILLER_19_375 VPWR VGND sg13g2_decap_4
XFILLER_62_632 VPWR VGND sg13g2_decap_4
XFILLER_62_676 VPWR VGND sg13g2_fill_2
X_5760_ _5760_/Y _5772_/A1 _5758_/Y _5759_/Y VPWR VGND sg13g2_a21oi_1
XFILLER_61_164 VPWR VGND sg13g2_fill_1
XFILLER_22_518 VPWR VGND sg13g2_decap_8
X_4711_ _4714_/B _9547_/Q _9548_/Q _8742_/Q VPWR VGND sg13g2_nor3_1
X_5691_ _5692_/A _8600_/Q _5693_/A2 _5693_/B1 _5691_/B2 VPWR VGND sg13g2_a22oi_1
X_4642_ _4642_/Y _4713_/B _4715_/A _5491_/C VPWR VGND sg13g2_o21ai_1
X_7430_ _7433_/A _7424_/Y _7429_/Y _7512_/B1 VPWR VGND sg13g2_o21ai_1
Xplace2103 _7767_/B _7782_/B VPWR VGND sg13g2_buf_1
XFILLER_116_601 VPWR VGND sg13g2_decap_8
Xplace2136 _5280_/A _5243_/B VPWR VGND sg13g2_buf_1
Xplace2114 _8083_/D _4560_/B VPWR VGND sg13g2_buf_1
X_7361_ _8901_/D _8901_/Q _7360_/Y _7848_/S VPWR VGND sg13g2_mux2_1
X_4573_ _9708_/D _4573_/A _4590_/C VPWR VGND sg13g2_nor2b_1
Xplace2125 _6506_/B1 _6077_/A VPWR VGND sg13g2_buf_1
Xplace2147 _5098_/A _8530_/B VPWR VGND sg13g2_buf_1
X_9100_ _9100_/Q _9603_/CLK _9100_/D place2411/X VPWR VGND sg13g2_dfrbpq_1
Xplace2158 _7627_/B _7804_/B VPWR VGND sg13g2_buf_1
X_6312_ _6312_/X _6312_/A _6312_/B _6312_/C VPWR VGND sg13g2_and3_1
X_7292_ _7294_/C _7425_/C _7297_/B _9085_/Q VPWR VGND sg13g2_nor3_1
XFILLER_7_780 VPWR VGND sg13g2_fill_2
Xplace2169 _6541_/B _5416_/B VPWR VGND sg13g2_buf_1
X_9031_ _9031_/Q _9188_/CLK _9031_/D place2483/X VPWR VGND sg13g2_dfrbpq_1
X_6243_ _6243_/Y _8854_/Q _6496_/A2 _6242_/X _6422_/B1 _6484_/S VPWR VGND sg13g2_a221oi_1
X_6174_ _6174_/Y _6169_/Y _6173_/X _6319_/C1 VPWR VGND sg13g2_a21oi_1
XFILLER_97_584 VPWR VGND sg13g2_decap_8
X_5125_ _5187_/C _5126_/B _5146_/D _6519_/D VPWR VGND sg13g2_nor3_1
X_5056_ _5735_/D _9261_/Q _5096_/C VPWR VGND sg13g2_nor2_1
XFILLER_85_779 VPWR VGND sg13g2_fill_2
XFILLER_84_223 VPWR VGND sg13g2_decap_4
XFILLER_84_256 VPWR VGND sg13g2_fill_2
XFILLER_38_651 VPWR VGND sg13g2_fill_2
X_9864_ _9864_/X _9864_/A VPWR VGND sg13g2_buf_1
X_8815_ _8815_/Q _9219_/CLK _8815_/D place2422/X VPWR VGND sg13g2_dfrbpq_1
XFILLER_52_153 VPWR VGND sg13g2_fill_1
X_5958_ _9321_/D _5960_/B _5956_/Y _5957_/Y VPWR VGND sg13g2_o21ai_1
XFILLER_80_473 VPWR VGND sg13g2_decap_8
X_8746_ _8746_/Q _9253_/CLK _8746_/D place2456/X VPWR VGND sg13g2_dfrbpq_1
XFILLER_71_39 VPWR VGND sg13g2_fill_1
X_4909_ _4909_/Y _4750_/A _4750_/B _4833_/A _4765_/Y VPWR VGND sg13g2_a22oi_1
X_5889_ _5889_/X _6004_/A _5953_/B2 _5889_/S VPWR VGND sg13g2_mux2_1
X_8677_ _8677_/Q _8678_/CLK _8677_/D fanout944/X VPWR VGND sg13g2_dfrbpq_1
X_7628_ _7630_/C _7759_/A _7799_/B _8978_/Q VPWR VGND sg13g2_nor3_1
X_7559_ _7560_/C _9874_/A _7825_/A2 _7825_/B1 _7559_/B2 VPWR VGND sg13g2_a22oi_1
XFILLER_20_10 VPWR VGND sg13g2_decap_4
XFILLER_107_634 VPWR VGND sg13g2_fill_1
X_9229_ _9229_/Q _9254_/CLK _9229_/D place2462/X VPWR VGND sg13g2_dfrbpq_1
XFILLER_121_103 VPWR VGND sg13g2_fill_2
Xplace1980 _5570_/B _5579_/B VPWR VGND sg13g2_buf_1
XFILLER_106_188 VPWR VGND sg13g2_decap_4
XFILLER_96_25 VPWR VGND sg13g2_decap_8
Xplace1991 _7824_/B _7660_/A2 VPWR VGND sg13g2_buf_1
XFILLER_76_746 VPWR VGND sg13g2_fill_1
XFILLER_17_802 VPWR VGND sg13g2_decap_8
XFILLER_16_301 VPWR VGND sg13g2_decap_4
XFILLER_16_323 VPWR VGND sg13g2_decap_8
XFILLER_71_495 VPWR VGND sg13g2_fill_1
XFILLER_71_473 VPWR VGND sg13g2_decap_8
Xinput2570 _7400_/A1 hartinfo_i[8] VPWR VGND sg13g2_buf_1
Xinput2592 _5946_/B2 master_rdata_i[22] VPWR VGND sg13g2_buf_1
Xinput2581 _5929_/A master_rdata_i[12] VPWR VGND sg13g2_buf_1
XFILLER_8_588 VPWR VGND sg13g2_fill_1
XFILLER_6_78 VPWR VGND sg13g2_fill_2
XFILLER_79_551 VPWR VGND sg13g2_decap_4
XFILLER_3_293 VPWR VGND sg13g2_decap_8
XFILLER_67_735 VPWR VGND sg13g2_fill_2
XFILLER_86_80 VPWR VGND sg13g2_decap_4
XFILLER_39_459 VPWR VGND sg13g2_fill_2
XFILLER_82_716 VPWR VGND sg13g2_fill_1
XFILLER_82_705 VPWR VGND sg13g2_decap_8
XFILLER_81_215 VPWR VGND sg13g2_decap_8
XFILLER_19_172 VPWR VGND sg13g2_decap_8
X_6930_ _6931_/B _9706_/Q _6937_/B VPWR VGND sg13g2_nand2_1
X_6861_ _6861_/X _8904_/Q _8936_/Q _6877_/S VPWR VGND sg13g2_mux2_1
XFILLER_34_142 VPWR VGND sg13g2_decap_8
XFILLER_35_654 VPWR VGND sg13g2_decap_8
X_9580_ _9580_/Q _9588_/CLK _9580_/D _9580_/RESET_B VPWR VGND sg13g2_dfrbpq_1
X_5812_ _5813_/A _9299_/Q _5786_/Y _5787_/Y _9496_/Q VPWR VGND sg13g2_a22oi_1
X_6792_ _9548_/D _6791_/B _6790_/Y _6791_/Y VPWR VGND sg13g2_a21oi_1
X_8600_ _8600_/Q _9708_/CLK _8600_/D fanout947/X VPWR VGND sg13g2_dfrbpq_1
X_8531_ _8534_/C _8540_/A _8532_/B _8532_/C _8532_/D VPWR VGND sg13g2_and4_1
X_5743_ _5743_/Y _5771_/A1 _9306_/Q _5763_/B1 VPWR VGND sg13g2_a21oi_1
XFILLER_96_0 VPWR VGND sg13g2_decap_8
X_5674_ _8590_/D _5674_/A VPWR VGND sg13g2_inv_1
X_8462_ _8462_/Y _8492_/A _9236_/Q _8490_/C VPWR VGND sg13g2_nand3_1
X_4625_ _8719_/D _6692_/A _6692_/B _6692_/D VPWR VGND sg13g2_nand3_1
X_7413_ _7416_/A _7407_/Y _7412_/Y _7571_/B1 VPWR VGND sg13g2_o21ai_1
X_8393_ _8393_/Y _8411_/A _9197_/Q _8411_/C VPWR VGND sg13g2_nand3_1
XFILLER_116_431 VPWR VGND sg13g2_fill_2
X_4556_ _4556_/Y _9213_/Q _7519_/C _7431_/D _9215_/Q _7775_/A VPWR VGND sg13g2_a221oi_1
X_7344_ _7348_/C _9181_/Q _7381_/B _7389_/A VPWR VGND sg13g2_o21ai_1
XFILLER_2_709 VPWR VGND sg13g2_decap_8
XFILLER_116_475 VPWR VGND sg13g2_decap_8
XFILLER_104_648 VPWR VGND sg13g2_decap_4
XFILLER_103_114 VPWR VGND sg13g2_decap_8
X_4487_ _9642_/D _5593_/B1 _4487_/A2 _4486_/Y VPWR VGND sg13g2_a21oi_1
X_7275_ _7275_/Y _7275_/A _7275_/B _7275_/C _7275_/D VPWR VGND sg13g2_nor4_1
X_6226_ _6226_/Y _8446_/B _6333_/B _6438_/C _6270_/C VPWR VGND sg13g2_nor4_1
X_9014_ _9014_/Q clkload7/A _9014_/D place2476/X VPWR VGND sg13g2_dfrbpq_1
XFILLER_103_169 VPWR VGND sg13g2_fill_1
X_6157_ _9353_/D _6279_/A _6155_/Y _6156_/Y VPWR VGND sg13g2_a21oi_1
X_5108_ _8029_/D _8355_/C _9474_/Q VPWR VGND sg13g2_and2_1
XFILLER_58_779 VPWR VGND sg13g2_fill_2
X_6088_ _6145_/B _6348_/D _6171_/C VPWR VGND sg13g2_xnor2_1
X_5039_ _5039_/Y _5070_/C _6519_/B _6519_/C _9408_/Q VPWR VGND sg13g2_a22oi_1
XFILLER_81_782 VPWR VGND sg13g2_fill_2
XFILLER_53_484 VPWR VGND sg13g2_decap_8
XFILLER_15_10 VPWR VGND sg13g2_decap_4
XFILLER_15_21 VPWR VGND sg13g2_decap_4
XFILLER_41_624 VPWR VGND sg13g2_fill_2
XFILLER_53_495 VPWR VGND sg13g2_fill_2
XFILLER_25_186 VPWR VGND sg13g2_fill_1
XFILLER_41_657 VPWR VGND sg13g2_fill_1
X_8729_ _8729_/Q _9672_/CLK _8729_/D place2440/X VPWR VGND sg13g2_dfrbpq_1
XFILLER_15_87 VPWR VGND sg13g2_fill_1
XFILLER_40_156 VPWR VGND sg13g2_decap_4
XFILLER_31_31 VPWR VGND sg13g2_fill_2
XFILLER_31_53 VPWR VGND sg13g2_fill_2
XFILLER_107_497 VPWR VGND sg13g2_fill_1
XFILLER_103_670 VPWR VGND sg13g2_decap_4
Xhold3180 _4488_/A _9639_/Q VPWR VGND sg13g2_dlygate4sd3_1
XFILLER_49_768 VPWR VGND sg13g2_fill_2
XFILLER_0_285 VPWR VGND sg13g2_fill_1
Xhold3191 _8317_/A _9159_/Q VPWR VGND sg13g2_dlygate4sd3_1
XFILLER_48_212 VPWR VGND sg13g2_fill_2
XFILLER_48_245 VPWR VGND sg13g2_decap_4
XFILLER_91_524 VPWR VGND sg13g2_fill_2
XFILLER_56_72 VPWR VGND sg13g2_decap_8
XFILLER_91_568 VPWR VGND sg13g2_fill_2
XFILLER_17_654 VPWR VGND sg13g2_decap_8
XFILLER_16_142 VPWR VGND sg13g2_decap_8
Xoutput2704 master_wdata_o[15] _5740_/Y VPWR VGND sg13g2_buf_1
XFILLER_8_396 VPWR VGND sg13g2_decap_8
X_4410_ _4411_/A _9702_/Q _6737_/C VPWR VGND sg13g2_nand2b_1
Xoutput2715 master_wdata_o[25] _5774_/X VPWR VGND sg13g2_buf_1
X_5390_ _8750_/D _8563_/A _5390_/B VPWR VGND sg13g2_nor2_1
Xoutput2726 master_wdata_o[6] _5715_/X VPWR VGND sg13g2_buf_1
Xoutput2737 slave_rdata_o[14] _4901_/Y VPWR VGND sg13g2_buf_1
Xoutput2748 slave_rdata_o[24] _4974_/Y VPWR VGND sg13g2_buf_1
XFILLER_98_112 VPWR VGND sg13g2_fill_1
X_4341_ _8730_/D _8735_/Q VPWR VGND sg13g2_inv_1
Xoutput2759 slave_rdata_o[5] _4818_/Y VPWR VGND sg13g2_buf_1
XFILLER_87_808 VPWR VGND sg13g2_fill_1
X_7060_ _8840_/D _7059_/A _7058_/Y _7059_/Y VPWR VGND sg13g2_o21ai_1
XFILLER_101_618 VPWR VGND sg13g2_decap_8
X_9504__2876 _9504_/RESET_B VPWR VGND sg13g2_tiehi
X_6011_ _9342_/D _4816_/A _6046_/D _6539_/S VPWR VGND sg13g2_mux2_1
XFILLER_82_502 VPWR VGND sg13g2_fill_2
X_7962_ _8991_/D _5345_/C _7979_/A _7961_/Y VPWR VGND sg13g2_o21ai_1
XFILLER_82_557 VPWR VGND sg13g2_decap_8
X_6913_ _9622_/D _9622_/Q _6912_/C _6912_/Y VPWR VGND sg13g2_a21o_1
XFILLER_54_248 VPWR VGND sg13g2_decap_8
X_9701_ _9701_/Q _9701_/CLK _9701_/D fanout952/X VPWR VGND sg13g2_dfrbpq_1
X_7893_ _8961_/D _5346_/C _7899_/A _7891_/Y VPWR VGND sg13g2_o21ai_1
X_9632_ _9632_/Q _9701_/CLK _9632_/D fanout952/X VPWR VGND sg13g2_dfrbpq_1
XFILLER_35_462 VPWR VGND sg13g2_fill_2
X_6844_ _8503_/B _9256_/Q _9257_/Q _8510_/A VPWR VGND sg13g2_o21ai_1
XFILLER_62_270 VPWR VGND sg13g2_decap_8
XFILLER_23_646 VPWR VGND sg13g2_fill_1
X_6775_ _9534_/D _9534_/Q _9444_/Q _6779_/S VPWR VGND sg13g2_mux2_1
X_9563_ _9563_/Q _9587_/CLK _9563_/D _9563_/RESET_B VPWR VGND sg13g2_dfrbpq_1
XFILLER_22_167 VPWR VGND sg13g2_decap_4
XFILLER_23_679 VPWR VGND sg13g2_fill_1
X_9494_ _9494_/Q _9621_/CLK _9494_/D _9494_/RESET_B VPWR VGND sg13g2_dfrbpq_1
X_5726_ _5726_/Y _5735_/A _5735_/B _9309_/Q _5735_/D VPWR VGND sg13g2_nand4_1
X_8514_ _9258_/D _8744_/Q _8514_/B _8514_/C VPWR VGND sg13g2_nor3_1
XFILLER_10_329 VPWR VGND sg13g2_fill_2
X_8445_ _9227_/D _8444_/A _5373_/C _8444_/Y VPWR VGND sg13g2_o21ai_1
X_5657_ _5657_/Y _5657_/A _5660_/B VPWR VGND sg13g2_nor2_1
XFILLER_117_773 VPWR VGND sg13g2_decap_8
X_5588_ _5588_/Y _5597_/A _5597_/B _8652_/Q _5597_/D VPWR VGND sg13g2_nand4_1
X_4608_ _8515_/C _6534_/A _6534_/B _5070_/C VPWR VGND sg13g2_nor3_1
X_8376_ _9188_/D _5356_/C _8375_/A _8375_/Y VPWR VGND sg13g2_o21ai_1
XFILLER_117_784 VPWR VGND sg13g2_fill_2
XFILLER_116_250 VPWR VGND sg13g2_decap_8
X_4539_ _7831_/C _7244_/D _6972_/C VPWR VGND sg13g2_nor2_1
X_7327_ _7330_/A _7333_/A _7351_/B _9087_/Q VPWR VGND sg13g2_nor3_1
XFILLER_2_517 VPWR VGND sg13g2_decap_8
X_7258_ _7258_/Y _7258_/A _7258_/B _7258_/C _7258_/D VPWR VGND sg13g2_nor4_1
X_6209_ _6209_/Y _6055_/A _6379_/A2 _6209_/B1 VPWR VGND sg13g2_a21oi_1
X_7189_ _7189_/Y _6959_/Y _7187_/Y _7188_/Y VPWR VGND sg13g2_a21oi_1
XFILLER_73_535 VPWR VGND sg13g2_decap_8
XFILLER_26_31 VPWR VGND sg13g2_fill_1
XFILLER_26_473 VPWR VGND sg13g2_fill_1
XFILLER_81_590 VPWR VGND sg13g2_fill_1
XFILLER_14_668 VPWR VGND sg13g2_fill_1
XFILLER_41_498 VPWR VGND sg13g2_decap_8
XFILLER_22_690 VPWR VGND sg13g2_fill_1
XFILLER_42_63 VPWR VGND sg13g2_decap_8
XFILLER_108_751 VPWR VGND sg13g2_decap_8
XFILLER_123_721 VPWR VGND sg13g2_decap_4
XFILLER_5_388 VPWR VGND sg13g2_fill_2
XFILLER_123_754 VPWR VGND sg13g2_decap_8
XFILLER_69_808 VPWR VGND sg13g2_fill_1
XFILLER_5_399 VPWR VGND sg13g2_decap_4
XFILLER_96_638 VPWR VGND sg13g2_fill_1
XFILLER_3_35 VPWR VGND sg13g2_decap_8
XFILLER_67_71 VPWR VGND sg13g2_fill_1
XFILLER_37_716 VPWR VGND sg13g2_fill_1
XFILLER_91_321 VPWR VGND sg13g2_decap_8
XFILLER_49_587 VPWR VGND sg13g2_decap_8
XFILLER_83_92 VPWR VGND sg13g2_decap_4
XFILLER_60_730 VPWR VGND sg13g2_decap_8
X_4890_ _4890_/Y _4889_/Y _4888_/Y _4782_/D VPWR VGND sg13g2_o21ai_1
XFILLER_32_421 VPWR VGND sg13g2_fill_2
XFILLER_32_465 VPWR VGND sg13g2_decap_4
X_6560_ _6569_/C _6569_/B _6560_/B _6945_/A _6951_/A VPWR VGND sg13g2_nand4_1
XFILLER_118_515 VPWR VGND sg13g2_decap_8
X_5511_ _5511_/Y _9423_/Q _5615_/B _5523_/B1 _8625_/Q VPWR VGND sg13g2_a22oi_1
XFILLER_118_526 VPWR VGND sg13g2_fill_1
X_6491_ _9403_/D _6489_/Y _6491_/A2 _6490_/Y VPWR VGND sg13g2_a21oi_1
X_5442_ _8679_/D _5442_/A _5454_/B_N VPWR VGND sg13g2_nor2b_1
X_8230_ _9115_/D _8252_/A1 _7889_/Y _8229_/Y VPWR VGND sg13g2_o21ai_1
X_5373_ _8813_/D _5375_/A _5373_/B _5373_/C _5373_/D VPWR VGND sg13g2_nor4_1
XFILLER_59_0 VPWR VGND sg13g2_decap_8
X_8161_ _8161_/Y _9081_/Q _8161_/B VPWR VGND sg13g2_nand2_1
XFILLER_114_743 VPWR VGND sg13g2_fill_1
X_8092_ _8092_/Y _8092_/A _9497_/Q _8092_/C _8095_/D VPWR VGND sg13g2_nand4_1
X_4324_ _4324_/Y _9879_/A VPWR VGND sg13g2_inv_1
X_7112_ _7112_/Y _5368_/C _7130_/A2 _7111_/Y VPWR VGND sg13g2_o21ai_1
XFILLER_114_765 VPWR VGND sg13g2_fill_2
XFILLER_59_318 VPWR VGND sg13g2_fill_2
X_7043_ _7043_/Y _7892_/D _6966_/Y _7036_/X _4436_/D VPWR VGND sg13g2_a22oi_1
XFILLER_113_297 VPWR VGND sg13g2_decap_8
XFILLER_87_638 VPWR VGND sg13g2_decap_4
XFILLER_59_329 VPWR VGND sg13g2_decap_4
X_8994_ _8994_/Q clkload5/A _8994_/D place2497/X VPWR VGND sg13g2_dfrbpq_1
X_7945_ _8984_/D _5369_/C _7948_/A _7944_/Y VPWR VGND sg13g2_o21ai_1
XFILLER_63_29 VPWR VGND sg13g2_fill_1
XFILLER_63_18 VPWR VGND sg13g2_decap_8
XFILLER_36_760 VPWR VGND sg13g2_decap_4
X_7876_ _8949_/D _8949_/Q _7677_/Y _7881_/S VPWR VGND sg13g2_mux2_1
XFILLER_51_741 VPWR VGND sg13g2_fill_2
XFILLER_42_229 VPWR VGND sg13g2_fill_2
X_9615_ _9615_/Q _9615_/CLK _9615_/D _9615_/RESET_B VPWR VGND sg13g2_dfrbpq_1
X_6827_ _9575_/D _9608_/Q _9575_/Q _6834_/S VPWR VGND sg13g2_mux2_1
XFILLER_50_240 VPWR VGND sg13g2_decap_4
XFILLER_23_454 VPWR VGND sg13g2_fill_1
X_9546_ _9546_/Q _9645_/CLK _9546_/D fanout977/X VPWR VGND sg13g2_dfrbpq_1
XFILLER_23_498 VPWR VGND sg13g2_fill_2
X_6758_ _9517_/D _9517_/Q _9427_/Q _6783_/S VPWR VGND sg13g2_mux2_1
XFILLER_7_609 VPWR VGND sg13g2_decap_8
X_6689_ _9461_/D _9455_/Q _4672_/X _6688_/Y VPWR VGND sg13g2_o21ai_1
X_5709_ _5709_/X _5716_/A _9306_/Q _5716_/C VPWR VGND sg13g2_and3_1
X_9477_ _9477_/Q clkload6/A _9477_/D _9477_/RESET_B VPWR VGND sg13g2_dfrbpq_1
X_8428_ _8428_/Y _8428_/A _9218_/Q _8430_/C VPWR VGND sg13g2_nand3_1
XFILLER_105_710 VPWR VGND sg13g2_decap_4
X_8359_ _8359_/Y _8383_/A _9180_/Q _8361_/C VPWR VGND sg13g2_nand3_1
XFILLER_88_48 VPWR VGND sg13g2_decap_8
XFILLER_105_765 VPWR VGND sg13g2_decap_4
XFILLER_104_253 VPWR VGND sg13g2_decap_8
XFILLER_120_735 VPWR VGND sg13g2_decap_8
XFILLER_86_660 VPWR VGND sg13g2_fill_2
XFILLER_100_470 VPWR VGND sg13g2_fill_1
XFILLER_92_118 VPWR VGND sg13g2_decap_8
XFILLER_86_671 VPWR VGND sg13g2_decap_8
XFILLER_37_30 VPWR VGND sg13g2_fill_2
X_9608__2782 _9608_/RESET_B VPWR VGND sg13g2_tiehi
XFILLER_46_535 VPWR VGND sg13g2_decap_4
XFILLER_27_760 VPWR VGND sg13g2_decap_8
Xplace1809 _8401_/A _8407_/A VPWR VGND sg13g2_buf_1
XFILLER_6_653 VPWR VGND sg13g2_decap_8
XFILLER_6_631 VPWR VGND sg13g2_fill_1
XFILLER_115_529 VPWR VGND sg13g2_decap_8
XFILLER_108_592 VPWR VGND sg13g2_fill_1
XFILLER_5_174 VPWR VGND sg13g2_decap_8
XFILLER_96_479 VPWR VGND sg13g2_decap_8
XFILLER_83_129 VPWR VGND sg13g2_decap_8
XFILLER_49_384 VPWR VGND sg13g2_decap_8
XFILLER_37_524 VPWR VGND sg13g2_fill_2
XFILLER_64_321 VPWR VGND sg13g2_fill_1
XFILLER_25_708 VPWR VGND sg13g2_decap_8
X_5991_ _9332_/D _5990_/Y _9332_/Q _6006_/S VPWR VGND sg13g2_mux2_1
XFILLER_91_162 VPWR VGND sg13g2_fill_2
XFILLER_91_151 VPWR VGND sg13g2_fill_1
XFILLER_52_505 VPWR VGND sg13g2_decap_8
XFILLER_92_696 VPWR VGND sg13g2_fill_1
X_7730_ _7733_/C _7730_/A _8498_/B _7730_/C VPWR VGND sg13g2_nand3_1
X_4942_ _4942_/Y _9396_/Q _4934_/B _4868_/A _4957_/D VPWR VGND sg13g2_a22oi_1
X_7661_ _7661_/Y _7661_/A _7661_/B VPWR VGND sg13g2_nand2_1
XFILLER_33_763 VPWR VGND sg13g2_decap_8
X_6612_ _6612_/Y _8637_/Q _6666_/A2 _6611_/X VPWR VGND sg13g2_o21ai_1
XFILLER_60_571 VPWR VGND sg13g2_fill_1
X_9400_ _9400_/Q _9407_/CLK _9400_/D place2489/X VPWR VGND sg13g2_dfrbpq_1
X_4873_ _4873_/X _4842_/A _4766_/A _4791_/Y VPWR VGND sg13g2_a21o_1
XFILLER_20_424 VPWR VGND sg13g2_decap_4
XFILLER_32_284 VPWR VGND sg13g2_fill_2
XFILLER_119_802 VPWR VGND sg13g2_fill_2
X_7592_ _7595_/A _7586_/Y _7591_/Y _8083_/D VPWR VGND sg13g2_o21ai_1
X_9331_ _9331_/Q _9409_/CLK _9331_/D place2393/X VPWR VGND sg13g2_dfrbpq_1
XFILLER_20_479 VPWR VGND sg13g2_fill_2
X_6543_ _6543_/X _6558_/A _9415_/Q _6737_/A _6558_/D VPWR VGND sg13g2_and4_1
X_9262_ _9262_/Q _9305_/CLK _9262_/D place2407/X VPWR VGND sg13g2_dfrbpq_1
X_6474_ _6474_/Y _6472_/Y _6473_/Y _6455_/A VPWR VGND sg13g2_a21oi_1
XFILLER_106_529 VPWR VGND sg13g2_decap_8
X_8213_ _8213_/Y _9107_/Q _8221_/B VPWR VGND sg13g2_nand2_1
X_5425_ _8697_/D _5425_/A _6558_/D VPWR VGND sg13g2_nor2b_1
X_9193_ _9193_/Q _9199_/CLK _9193_/D place2424/X VPWR VGND sg13g2_dfrbpq_1
XFILLER_102_702 VPWR VGND sg13g2_decap_8
X_5356_ _8796_/D _5366_/A _5366_/B _5356_/C _5366_/D VPWR VGND sg13g2_nor4_1
X_8144_ _9072_/D _8160_/A1 _8074_/Y _8143_/Y VPWR VGND sg13g2_o21ai_1
XFILLER_87_424 VPWR VGND sg13g2_fill_2
X_5287_ _5287_/Y _5287_/A _5287_/B VPWR VGND sg13g2_nand2_1
X_8075_ _9041_/D _6994_/D _8074_/Y _8073_/Y VPWR VGND sg13g2_o21ai_1
X_4307_ _6951_/A _9634_/Q VPWR VGND sg13g2_inv_1
X_7026_ _7026_/Y _7026_/A _8285_/B VPWR VGND sg13g2_nand2_1
XFILLER_75_619 VPWR VGND sg13g2_fill_2
XFILLER_59_159 VPWR VGND sg13g2_decap_8
XFILLER_74_118 VPWR VGND sg13g2_decap_8
XFILLER_82_151 VPWR VGND sg13g2_decap_8
X_8977_ _8977_/Q clkload6/A _8977_/D place2464/X VPWR VGND sg13g2_dfrbpq_1
X_7928_ _7928_/Y _8403_/C _9488_/Q _7951_/C VPWR VGND sg13g2_nand3_1
XFILLER_43_538 VPWR VGND sg13g2_decap_8
XFILLER_70_346 VPWR VGND sg13g2_decap_8
X_7859_ _7859_/Y _9258_/Q _8513_/B _7859_/B1 VPWR VGND sg13g2_a21oi_1
XFILLER_90_49 VPWR VGND sg13g2_decap_8
XFILLER_51_582 VPWR VGND sg13g2_fill_2
XFILLER_23_10 VPWR VGND sg13g2_decap_8
XFILLER_24_785 VPWR VGND sg13g2_fill_1
XFILLER_11_435 VPWR VGND sg13g2_decap_4
X_9529_ _9529_/Q _9582_/CLK _9529_/D _9529_/RESET_B VPWR VGND sg13g2_dfrbpq_1
XFILLER_11_479 VPWR VGND sg13g2_decap_4
XFILLER_109_389 VPWR VGND sg13g2_decap_8
XFILLER_120_521 VPWR VGND sg13g2_fill_2
XFILLER_2_177 VPWR VGND sg13g2_decap_8
XFILLER_120_598 VPWR VGND sg13g2_decap_4
XFILLER_74_641 VPWR VGND sg13g2_fill_2
XFILLER_0_14 VPWR VGND sg13g2_decap_8
XFILLER_19_568 VPWR VGND sg13g2_decap_8
XFILLER_64_72 VPWR VGND sg13g2_fill_2
XFILLER_27_590 VPWR VGND sg13g2_decap_8
XFILLER_30_733 VPWR VGND sg13g2_fill_1
XFILLER_30_744 VPWR VGND sg13g2_fill_2
XFILLER_30_755 VPWR VGND sg13g2_decap_8
Xplace2307 _5055_/A _9261_/Q VPWR VGND sg13g2_buf_1
Xplace2318 _6905_/S _9255_/Q VPWR VGND sg13g2_buf_1
Xplace2329 _5008_/A _4944_/A VPWR VGND sg13g2_buf_1
XFILLER_6_461 VPWR VGND sg13g2_decap_8
XFILLER_115_326 VPWR VGND sg13g2_decap_8
X_5210_ _5243_/B _9866_/A _9867_/A _9868_/A _9869_/A VPWR VGND sg13g2_and4_1
Xhold3009 _4663_/A _8717_/Q VPWR VGND sg13g2_dlygate4sd3_1
X_6190_ _6191_/B _9250_/Q _6262_/A _6262_/C _6190_/D VPWR VGND sg13g2_and4_1
X_5141_ _5348_/C _8399_/C _9475_/Q VPWR VGND sg13g2_nand2_1
X_5072_ _8563_/C _7245_/B _7245_/C _7032_/D _5376_/B VPWR VGND sg13g2_nand4_1
X_8900_ _8900_/Q _9198_/CLK _8900_/D place2451/X VPWR VGND sg13g2_dfrbpq_1
X_9880_ _9880_/X _9880_/A VPWR VGND sg13g2_buf_1
XFILLER_77_490 VPWR VGND sg13g2_decap_8
X_8831_ _8831_/Q _9620_/CLK _8831_/D place2430/X VPWR VGND sg13g2_dfrbpq_1
X_9541__2839 _9541_/RESET_B VPWR VGND sg13g2_tiehi
XFILLER_92_471 VPWR VGND sg13g2_decap_8
X_8762_ _9868_/A _9252_/CLK _8762_/D place2390/X VPWR VGND sg13g2_dfrbpq_1
X_5974_ _5974_/Y _9492_/Q _5980_/A2 _5873_/X _5980_/B2 VPWR VGND sg13g2_a22oi_1
X_7713_ _7714_/C _7713_/A1 _7846_/B1 _7712_/X _7831_/C VPWR VGND sg13g2_a22oi_1
XFILLER_52_368 VPWR VGND sg13g2_fill_1
X_8693_ _8693_/Q _9630_/CLK _8693_/D fanout955/X VPWR VGND sg13g2_dfrbpq_1
X_4925_ _4925_/Y _4924_/Y _4925_/A2 _4861_/Y VPWR VGND sg13g2_a21oi_1
XFILLER_33_571 VPWR VGND sg13g2_decap_8
XFILLER_40_519 VPWR VGND sg13g2_decap_4
X_7644_ _7647_/C _7644_/A _7644_/B _8979_/Q VPWR VGND sg13g2_nor3_1
X_4856_ _4856_/Y _4777_/B _6010_/A0 _4816_/A VPWR VGND sg13g2_a21oi_1
XFILLER_20_232 VPWR VGND sg13g2_decap_8
XFILLER_33_593 VPWR VGND sg13g2_decap_4
XFILLER_119_610 VPWR VGND sg13g2_decap_8
X_7575_ _7575_/Y _7829_/A _7575_/B VPWR VGND sg13g2_nor2_1
X_9314_ _9314_/Q _9410_/CLK _9314_/D place2398/X VPWR VGND sg13g2_dfrbpq_1
X_6526_ _6526_/X _9266_/Q _7482_/C _7519_/D VPWR VGND sg13g2_and3_1
X_4787_ _4787_/Y _9379_/Q _4770_/Y _4786_/Y VPWR VGND sg13g2_a21oi_1
XFILLER_119_687 VPWR VGND sg13g2_fill_1
XFILLER_119_676 VPWR VGND sg13g2_decap_8
X_6457_ _6457_/Y _6512_/A1 _6512_/A2 _6457_/B1 VPWR VGND sg13g2_a21oi_1
X_9245_ _9245_/Q _9251_/CLK _9245_/D place2480/X VPWR VGND sg13g2_dfrbpq_1
X_5408_ _8746_/D _5414_/B _5395_/Y _5407_/Y VPWR VGND sg13g2_a21oi_1
X_9176_ _9176_/Q _9242_/CLK _9176_/D place2494/X VPWR VGND sg13g2_dfrbpq_1
X_6388_ _9385_/D _6056_/Y _6386_/Y _6387_/Y VPWR VGND sg13g2_a21oi_1
X_5339_ _5339_/Y _9889_/A _5339_/B _5339_/C _5339_/D VPWR VGND sg13g2_nor4_1
X_8127_ _8127_/Y _9064_/Q _8129_/B VPWR VGND sg13g2_nand2_1
XFILLER_87_276 VPWR VGND sg13g2_fill_2
XFILLER_85_27 VPWR VGND sg13g2_decap_8
XFILLER_18_10 VPWR VGND sg13g2_fill_2
XFILLER_29_800 VPWR VGND sg13g2_fill_1
X_8058_ _8058_/Y _9035_/Q _8101_/B VPWR VGND sg13g2_nand2_1
X_7009_ _8825_/D _5337_/Y _7946_/A _7007_/Y VPWR VGND sg13g2_o21ai_1
XFILLER_83_493 VPWR VGND sg13g2_decap_8
XFILLER_83_482 VPWR VGND sg13g2_fill_1
X_9517__2863 _9517_/RESET_B VPWR VGND sg13g2_tiehi
XFILLER_71_699 VPWR VGND sg13g2_decap_8
XFILLER_70_165 VPWR VGND sg13g2_fill_1
XFILLER_24_582 VPWR VGND sg13g2_fill_1
XFILLER_8_704 VPWR VGND sg13g2_fill_2
XFILLER_12_744 VPWR VGND sg13g2_decap_8
XFILLER_12_755 VPWR VGND sg13g2_fill_2
XFILLER_24_593 VPWR VGND sg13g2_decap_4
XFILLER_109_120 VPWR VGND sg13g2_decap_4
XFILLER_109_153 VPWR VGND sg13g2_decap_8
XFILLER_50_96 VPWR VGND sg13g2_fill_2
XFILLER_112_318 VPWR VGND sg13g2_decap_8
XFILLER_79_733 VPWR VGND sg13g2_decap_4
XFILLER_79_711 VPWR VGND sg13g2_decap_8
XFILLER_3_464 VPWR VGND sg13g2_decap_8
XFILLER_78_221 VPWR VGND sg13g2_fill_2
XFILLER_59_94 VPWR VGND sg13g2_fill_2
XFILLER_39_608 VPWR VGND sg13g2_fill_1
XFILLER_93_213 VPWR VGND sg13g2_decap_8
XFILLER_47_641 VPWR VGND sg13g2_decap_8
XFILLER_47_630 VPWR VGND sg13g2_fill_1
XFILLER_74_493 VPWR VGND sg13g2_fill_2
XFILLER_47_685 VPWR VGND sg13g2_decap_8
X_4710_ _9670_/D _6955_/S _4708_/B _4709_/Y VPWR VGND sg13g2_o21ai_1
X_5690_ _8598_/D _5690_/A VPWR VGND sg13g2_inv_1
X_4641_ _4713_/B _9547_/Q _9548_/Q VPWR VGND sg13g2_nand2_1
XFILLER_30_585 VPWR VGND sg13g2_decap_8
Xplace2137 _5178_/A _5147_/D VPWR VGND sg13g2_buf_1
Xplace2126 _5375_/C _5337_/Y VPWR VGND sg13g2_buf_1
Xplace2104 _7782_/B _7719_/B VPWR VGND sg13g2_buf_1
Xplace2115 _8095_/D _4560_/B VPWR VGND sg13g2_buf_1
X_7360_ _7360_/Y _7359_/Y _7354_/Y _7459_/A VPWR VGND sg13g2_a21oi_1
X_4572_ _4573_/A _4572_/A _4572_/B VPWR VGND sg13g2_nor2_1
XFILLER_116_657 VPWR VGND sg13g2_fill_2
Xplace2159 _7804_/B _7724_/B VPWR VGND sg13g2_buf_1
X_6311_ _6312_/B _8861_/Q _6462_/A2 _6310_/X _6434_/A2 _6309_/Y VPWR VGND sg13g2_a221oi_1
X_7291_ _7294_/B _9147_/Q _7291_/B VPWR VGND sg13g2_nor2_1
Xplace2148 _4998_/B _4777_/B VPWR VGND sg13g2_buf_1
X_6242_ _6242_/X _8980_/Q _9042_/Q _9104_/Q _9166_/Q _6440_/S0 _6421_/S1 VPWR VGND
+ sg13g2_mux4_1
X_9030_ _9030_/Q _9188_/CLK _9030_/D place2474/X VPWR VGND sg13g2_dfrbpq_1
X_9567__2823 _9567_/RESET_B VPWR VGND sg13g2_tiehi
XFILLER_41_0 VPWR VGND sg13g2_decap_4
XFILLER_97_552 VPWR VGND sg13g2_fill_2
X_6173_ _6173_/X _6173_/A _6399_/B _6173_/C _6173_/D VPWR VGND sg13g2_or4_1
X_5124_ _5178_/B _5124_/A _5124_/B _6519_/C _6519_/B VPWR VGND sg13g2_nor4_1
XFILLER_85_714 VPWR VGND sg13g2_fill_2
XFILLER_57_416 VPWR VGND sg13g2_decap_4
X_5055_ _5055_/Y _5055_/A _5057_/A _5098_/A _5055_/D VPWR VGND sg13g2_nor4_1
XFILLER_85_758 VPWR VGND sg13g2_decap_8
XFILLER_57_438 VPWR VGND sg13g2_decap_8
X_9863_ _9863_/X _9863_/A VPWR VGND sg13g2_buf_1
XFILLER_72_408 VPWR VGND sg13g2_decap_4
XFILLER_65_460 VPWR VGND sg13g2_decap_8
XFILLER_38_663 VPWR VGND sg13g2_decap_4
X_8814_ _8814_/Q _9219_/CLK _8814_/D place2422/X VPWR VGND sg13g2_dfrbpq_1
XFILLER_65_471 VPWR VGND sg13g2_fill_1
XFILLER_53_622 VPWR VGND sg13g2_fill_1
XFILLER_53_655 VPWR VGND sg13g2_decap_8
X_5957_ _5957_/Y _9321_/Q _5960_/B VPWR VGND sg13g2_nand2_1
X_8745_ _9221_/D _9219_/CLK _8745_/D place2402/X VPWR VGND sg13g2_dfrbpq_1
XFILLER_13_519 VPWR VGND sg13g2_decap_4
X_8676_ _8676_/Q _8678_/CLK _8676_/D fanout944/X VPWR VGND sg13g2_dfrbpq_1
X_4908_ _4908_/Y _4842_/Y _4995_/S _4847_/Y VPWR VGND sg13g2_a21oi_1
X_5888_ _5888_/Y _5781_/A _9478_/Q VPWR VGND sg13g2_nand2b_1
X_7627_ _7630_/B _9071_/Q _7627_/B VPWR VGND sg13g2_nor2_1
X_4839_ _4839_/Y _4782_/Y _4838_/Y _4853_/A VPWR VGND sg13g2_a21oi_1
XFILLER_21_596 VPWR VGND sg13g2_fill_2
X_7558_ _7560_/B _8849_/Q _7579_/A2 _7269_/X _8819_/Q VPWR VGND sg13g2_a22oi_1
XFILLER_119_495 VPWR VGND sg13g2_fill_2
XFILLER_119_484 VPWR VGND sg13g2_fill_1
X_7489_ _7489_/Y _7489_/A _7489_/B _7489_/C _7489_/D VPWR VGND sg13g2_nor4_1
X_6509_ _6510_/A _6509_/A _6509_/B _6509_/C _6509_/D VPWR VGND sg13g2_nand4_1
X_9228_ _9228_/Q _9251_/CLK _9228_/D place2478/X VPWR VGND sg13g2_dfrbpq_1
XFILLER_122_616 VPWR VGND sg13g2_fill_1
Xplace1970 _7557_/A2 _7796_/A2 VPWR VGND sg13g2_buf_1
Xplace1981 _5579_/B _5591_/B VPWR VGND sg13g2_buf_1
XFILLER_20_99 VPWR VGND sg13g2_decap_8
Xplace1992 _7660_/A2 _7787_/B VPWR VGND sg13g2_buf_1
XFILLER_0_445 VPWR VGND sg13g2_decap_8
X_9159_ _9159_/Q clkload8/A _9159_/D place2468/X VPWR VGND sg13g2_dfrbpq_1
XFILLER_0_456 VPWR VGND sg13g2_fill_2
XFILLER_29_630 VPWR VGND sg13g2_fill_1
XFILLER_29_674 VPWR VGND sg13g2_fill_2
XFILLER_90_227 VPWR VGND sg13g2_fill_1
XFILLER_45_96 VPWR VGND sg13g2_decap_8
Xinput2560 _7809_/B2 hartinfo_i[28] VPWR VGND sg13g2_buf_1
XFILLER_8_523 VPWR VGND sg13g2_fill_1
Xinput2593 _5953_/B2 master_rdata_i[23] VPWR VGND sg13g2_buf_1
Xinput2582 _5936_/B master_rdata_i[13] VPWR VGND sg13g2_buf_1
Xinput2571 _7432_/B2 hartinfo_i[9] VPWR VGND sg13g2_buf_1
XFILLER_6_35 VPWR VGND sg13g2_decap_8
XFILLER_3_272 VPWR VGND sg13g2_decap_8
XFILLER_79_530 VPWR VGND sg13g2_decap_8
XFILLER_79_563 VPWR VGND sg13g2_fill_2
XFILLER_121_682 VPWR VGND sg13g2_fill_2
XFILLER_66_235 VPWR VGND sg13g2_decap_8
XFILLER_66_224 VPWR VGND sg13g2_fill_1
XFILLER_66_213 VPWR VGND sg13g2_decap_8
XFILLER_94_566 VPWR VGND sg13g2_fill_2
XFILLER_94_555 VPWR VGND sg13g2_decap_8
XFILLER_66_268 VPWR VGND sg13g2_fill_1
XFILLER_66_257 VPWR VGND sg13g2_decap_8
XFILLER_75_780 VPWR VGND sg13g2_decap_8
XFILLER_19_151 VPWR VGND sg13g2_decap_8
XFILLER_35_633 VPWR VGND sg13g2_decap_8
X_6860_ _9596_/D _6859_/X _9596_/Q _6906_/S VPWR VGND sg13g2_mux2_1
XFILLER_90_783 VPWR VGND sg13g2_decap_4
X_5811_ _9298_/D _5811_/A VPWR VGND sg13g2_inv_1
X_6791_ _6791_/Y _9548_/Q _6791_/B VPWR VGND sg13g2_nor2_1
X_8530_ _8532_/D _8530_/A _8530_/B _8530_/C _8530_/D VPWR VGND sg13g2_nand4_1
X_5742_ _5742_/Y _9314_/Q _5739_/A _5741_/Y VPWR VGND sg13g2_o21ai_1
XFILLER_89_0 VPWR VGND sg13g2_decap_8
X_8461_ _9235_/D _8470_/A _5349_/C _8460_/Y VPWR VGND sg13g2_o21ai_1
X_5673_ _5674_/A _8591_/Q _5677_/A2 _5677_/B1 _5673_/B2 VPWR VGND sg13g2_a22oi_1
X_9491__2889 _9491_/RESET_B VPWR VGND sg13g2_tiehi
X_4624_ _6692_/B _9461_/Q _4675_/A _9462_/Q VPWR VGND sg13g2_nand3b_1
X_7412_ _7412_/Y _7412_/A _7412_/B _7412_/C _7412_/D VPWR VGND sg13g2_nor4_1
X_8392_ _9196_/D _8489_/A2 _8411_/A _8391_/Y VPWR VGND sg13g2_o21ai_1
XFILLER_116_410 VPWR VGND sg13g2_decap_8
X_4555_ _4555_/Y _9216_/Q _4528_/X _7461_/C _9214_/Q VPWR VGND sg13g2_a22oi_1
X_7343_ _8900_/D _8900_/Q _7342_/Y _7848_/S VPWR VGND sg13g2_mux2_1
XFILLER_104_605 VPWR VGND sg13g2_decap_4
X_4486_ _4486_/Y _8718_/Q _9642_/Q _4666_/A VPWR VGND sg13g2_nor3_1
X_9013_ _9013_/Q _9199_/CLK _9013_/D place2423/X VPWR VGND sg13g2_dfrbpq_1
X_7274_ _7275_/C _9177_/Q _7815_/B _7299_/A VPWR VGND sg13g2_o21ai_1
X_6225_ _6438_/C _9230_/Q _6322_/B VPWR VGND sg13g2_nor2b_1
XFILLER_100_800 VPWR VGND sg13g2_fill_1
XFILLER_97_371 VPWR VGND sg13g2_fill_1
X_6156_ _6156_/Y _6415_/A1 _6470_/A2 _6156_/B1 VPWR VGND sg13g2_a21oi_1
XFILLER_97_382 VPWR VGND sg13g2_decap_8
X_5107_ _8754_/D _5080_/A _5104_/X _5346_/C _5080_/Y VPWR VGND sg13g2_a22oi_1
XFILLER_57_235 VPWR VGND sg13g2_decap_8
X_6087_ _9347_/D _6131_/D _6086_/Y _6084_/Y VPWR VGND sg13g2_a21oi_1
XFILLER_122_35 VPWR VGND sg13g2_decap_8
X_5038_ _5038_/Y _6534_/B _6519_/C VPWR VGND sg13g2_nand2_1
XFILLER_53_441 VPWR VGND sg13g2_fill_1
XFILLER_13_316 VPWR VGND sg13g2_fill_2
X_6989_ _6989_/Y _8828_/Q _7741_/B _7690_/A VPWR VGND sg13g2_nand3b_1
X_8728_ _8728_/Q _9672_/CLK _8728_/D place2440/X VPWR VGND sg13g2_dfrbpq_1
XFILLER_13_327 VPWR VGND sg13g2_fill_1
XFILLER_15_44 VPWR VGND sg13g2_fill_2
XFILLER_15_55 VPWR VGND sg13g2_fill_1
XFILLER_40_102 VPWR VGND sg13g2_fill_1
X_8659_ _8659_/Q _9511_/CLK _8659_/D fanout957/X VPWR VGND sg13g2_dfrbpq_1
XFILLER_31_43 VPWR VGND sg13g2_fill_2
XFILLER_5_537 VPWR VGND sg13g2_decap_8
Xplace2490 place2490/X place2491/X VPWR VGND sg13g2_buf_1
XFILLER_1_743 VPWR VGND sg13g2_decap_4
XFILLER_49_714 VPWR VGND sg13g2_fill_2
XFILLER_0_231 VPWR VGND sg13g2_fill_2
Xhold3192 _8573_/C _9279_/Q VPWR VGND sg13g2_dlygate4sd3_1
Xhold3181 _6580_/A _9426_/Q VPWR VGND sg13g2_dlygate4sd3_1
Xhold3170 _6204_/B1 _9359_/Q VPWR VGND sg13g2_dlygate4sd3_1
XFILLER_48_224 VPWR VGND sg13g2_decap_8
XFILLER_16_121 VPWR VGND sg13g2_decap_8
XFILLER_17_688 VPWR VGND sg13g2_decap_4
XFILLER_32_603 VPWR VGND sg13g2_fill_2
XFILLER_71_271 VPWR VGND sg13g2_fill_2
XFILLER_8_331 VPWR VGND sg13g2_decap_4
Xoutput2705 master_wdata_o[16] _5744_/Y VPWR VGND sg13g2_buf_1
Xoutput2716 master_wdata_o[26] _5775_/X VPWR VGND sg13g2_buf_1
Xoutput2727 master_wdata_o[7] _5716_/X VPWR VGND sg13g2_buf_1
Xoutput2738 slave_rdata_o[15] _4906_/Y VPWR VGND sg13g2_buf_1
XFILLER_113_402 VPWR VGND sg13g2_decap_8
X_4340_ _8736_/D _8729_/Q VPWR VGND sg13g2_inv_1
Xoutput2749 slave_rdata_o[25] _4980_/Y VPWR VGND sg13g2_buf_1
X_9476__2904 _9476_/RESET_B VPWR VGND sg13g2_tiehi
XFILLER_98_168 VPWR VGND sg13g2_fill_1
XFILLER_79_360 VPWR VGND sg13g2_decap_8
X_6010_ _9341_/D _6010_/A0 _6043_/B _6539_/S VPWR VGND sg13g2_mux2_1
XFILLER_79_371 VPWR VGND sg13g2_fill_1
XFILLER_67_599 VPWR VGND sg13g2_fill_1
XFILLER_54_227 VPWR VGND sg13g2_decap_8
X_7961_ _7961_/Y _7979_/A _8991_/Q _8353_/C VPWR VGND sg13g2_nand3_1
XFILLER_27_419 VPWR VGND sg13g2_decap_8
XFILLER_39_279 VPWR VGND sg13g2_decap_8
X_6912_ _6912_/Y _9622_/Q _8740_/D _6912_/C VPWR VGND sg13g2_nor3_1
X_7892_ _7892_/Y _8039_/A _8039_/B _8039_/C _7892_/D VPWR VGND sg13g2_nand4_1
X_9700_ _9700_/Q _9708_/CLK _9700_/D fanout953/X VPWR VGND sg13g2_dfrbpq_1
XFILLER_35_441 VPWR VGND sg13g2_decap_8
X_6843_ _8510_/A _8740_/D _8500_/C VPWR VGND sg13g2_nor2_1
XFILLER_62_260 VPWR VGND sg13g2_fill_1
X_9631_ _9631_/Q _9701_/CLK _9631_/D fanout951/X VPWR VGND sg13g2_dfrbpq_1
XFILLER_50_422 VPWR VGND sg13g2_fill_2
XFILLER_23_625 VPWR VGND sg13g2_decap_8
XFILLER_23_636 VPWR VGND sg13g2_fill_1
XFILLER_35_485 VPWR VGND sg13g2_fill_1
X_6774_ _9533_/D _9533_/Q _6774_/A1 _6779_/S VPWR VGND sg13g2_mux2_1
X_9562_ _9562_/Q _9587_/CLK _9562_/D _9562_/RESET_B VPWR VGND sg13g2_dfrbpq_1
XFILLER_22_146 VPWR VGND sg13g2_decap_8
X_9493_ _9493_/Q _9621_/CLK _9493_/D _9493_/RESET_B VPWR VGND sg13g2_dfrbpq_1
X_8513_ _8514_/C _9258_/Q _8513_/B VPWR VGND sg13g2_nor2_1
X_5725_ _5725_/Y _5762_/A1 _5740_/A2 _5723_/Y _5724_/Y VPWR VGND sg13g2_a22oi_1
Xclkbuf_1_0__f_jtag_tck_i clkbuf_1_0__f_jtag_tck_i/X clkbuf_0_jtag_tck_i/X VPWR VGND
+ sg13g2_buf_8
X_5656_ _8610_/D _5654_/Y _5655_/Y _5653_/Y VPWR VGND sg13g2_a21oi_1
X_8444_ _8444_/Y _8444_/A _9227_/Q _8444_/C VPWR VGND sg13g2_nand3_1
X_4607_ _6519_/C _6534_/A _5070_/C VPWR VGND sg13g2_nor2_1
X_5587_ _8650_/D _5586_/Y _5585_/Y _5587_/B1 VPWR VGND sg13g2_a21oi_1
X_8375_ _8375_/Y _8375_/A _9188_/Q _8375_/C VPWR VGND sg13g2_nand3_1
XFILLER_104_402 VPWR VGND sg13g2_decap_8
X_4538_ _6972_/C _4545_/C _7032_/C VPWR VGND sg13g2_nand2_1
X_7326_ _7330_/C _9180_/Q _7381_/B _7389_/A VPWR VGND sg13g2_o21ai_1
X_4469_ _4470_/B _9677_/Q _9676_/Q VPWR VGND sg13g2_nand2b_1
X_7257_ _7258_/D _9145_/Q _7291_/B _7299_/A VPWR VGND sg13g2_o21ai_1
X_6208_ _6208_/Y _8849_/Q _6411_/A2 _6207_/X _6401_/B2 _6319_/C1 VPWR VGND sg13g2_a221oi_1
X_7188_ _7188_/Y _7237_/A1 _9487_/Q _7229_/B1 _7229_/B2 VPWR VGND sg13g2_a22oi_1
X_6139_ _6516_/B _6399_/A _6410_/C VPWR VGND sg13g2_nor2_1
XFILLER_85_385 VPWR VGND sg13g2_fill_1
XFILLER_13_124 VPWR VGND sg13g2_fill_2
XFILLER_14_625 VPWR VGND sg13g2_decap_8
XFILLER_41_477 VPWR VGND sg13g2_decap_8
XFILLER_42_31 VPWR VGND sg13g2_decap_4
XFILLER_42_97 VPWR VGND sg13g2_decap_4
XFILLER_108_785 VPWR VGND sg13g2_fill_1
X_9595__2795 _9595_/RESET_B VPWR VGND sg13g2_tiehi
XFILLER_96_617 VPWR VGND sg13g2_decap_8
XFILLER_3_14 VPWR VGND sg13g2_decap_8
XFILLER_89_691 VPWR VGND sg13g2_fill_1
XFILLER_95_149 VPWR VGND sg13g2_fill_2
XFILLER_76_352 VPWR VGND sg13g2_fill_2
XFILLER_76_385 VPWR VGND sg13g2_decap_8
XFILLER_64_514 VPWR VGND sg13g2_fill_1
XFILLER_64_569 VPWR VGND sg13g2_fill_2
XFILLER_36_238 VPWR VGND sg13g2_decap_8
XFILLER_51_219 VPWR VGND sg13g2_fill_1
XFILLER_45_761 VPWR VGND sg13g2_decap_8
XFILLER_72_591 VPWR VGND sg13g2_decap_8
XFILLER_45_794 VPWR VGND sg13g2_fill_2
X_5510_ _5510_/Y _5525_/A _5525_/B _8626_/Q _5525_/D VPWR VGND sg13g2_nand4_1
XFILLER_118_538 VPWR VGND sg13g2_decap_8
X_6490_ _6490_/Y _6312_/C _6312_/A _6490_/B1 VPWR VGND sg13g2_a21oi_1
XFILLER_9_695 VPWR VGND sg13g2_fill_2
XFILLER_8_161 VPWR VGND sg13g2_decap_8
XFILLER_8_194 VPWR VGND sg13g2_fill_2
X_5441_ _5442_/A _5455_/A1 _8679_/Q _8680_/Q _5451_/B2 VPWR VGND sg13g2_a22oi_1
X_5372_ _8812_/D _7024_/C _5836_/C _5372_/C _5372_/D VPWR VGND sg13g2_nor4_1
X_8160_ _9080_/D _8160_/A1 _7951_/Y _8159_/Y VPWR VGND sg13g2_o21ai_1
X_8091_ _8091_/Y _8091_/A _8097_/B VPWR VGND sg13g2_nand2_1
X_4323_ _5254_/A _9876_/A VPWR VGND sg13g2_inv_1
X_7111_ _7111_/Y _7214_/B _7236_/D _7129_/C VPWR VGND sg13g2_nand3_1
XFILLER_101_405 VPWR VGND sg13g2_decap_8
X_7042_ _8834_/D _7050_/A _7040_/Y _7041_/Y VPWR VGND sg13g2_o21ai_1
XFILLER_103_15 VPWR VGND sg13g2_fill_2
XFILLER_95_683 VPWR VGND sg13g2_decap_4
XFILLER_55_514 VPWR VGND sg13g2_decap_8
X_8993_ _8993_/Q _9183_/CLK _8993_/D place2471/X VPWR VGND sg13g2_dfrbpq_1
X_7944_ _7944_/Y _7948_/A _8984_/Q _8401_/C VPWR VGND sg13g2_nand3_1
XFILLER_27_238 VPWR VGND sg13g2_fill_1
XFILLER_70_506 VPWR VGND sg13g2_fill_1
XFILLER_42_219 VPWR VGND sg13g2_fill_1
X_7875_ _8948_/D _8948_/Q _7657_/Y _7881_/S VPWR VGND sg13g2_mux2_1
XFILLER_82_399 VPWR VGND sg13g2_decap_8
XFILLER_23_422 VPWR VGND sg13g2_decap_8
X_9614_ _9614_/Q _9615_/CLK _9614_/D _9614_/RESET_B VPWR VGND sg13g2_dfrbpq_1
X_6826_ _9574_/D _9607_/Q _9574_/Q _6834_/S VPWR VGND sg13g2_mux2_1
XFILLER_23_444 VPWR VGND sg13g2_decap_4
X_9545_ _9545_/Q _9645_/CLK _9545_/D _9545_/RESET_B VPWR VGND sg13g2_dfrbpq_1
X_6757_ _9516_/D _9516_/Q _9426_/Q _6783_/S VPWR VGND sg13g2_mux2_1
XFILLER_11_628 VPWR VGND sg13g2_decap_4
X_5708_ _8738_/D _9677_/D _5708_/B VPWR VGND sg13g2_and2_1
X_6688_ _6688_/Y _4674_/C _4672_/X _6688_/B1 VPWR VGND sg13g2_o21ai_1
X_9476_ _9476_/Q _9501_/CLK _9476_/D _9476_/RESET_B VPWR VGND sg13g2_dfrbpq_1
XFILLER_109_549 VPWR VGND sg13g2_decap_8
X_8427_ _9217_/D _8489_/A2 _8428_/A _8426_/Y VPWR VGND sg13g2_o21ai_1
X_5639_ _5640_/B _4457_/X _5629_/A _5639_/B1 VPWR VGND sg13g2_a21oi_1
X_8358_ _9179_/D _5347_/C _8367_/A _8357_/Y VPWR VGND sg13g2_o21ai_1
X_7309_ _7313_/C _9179_/Q _7381_/B _7389_/A VPWR VGND sg13g2_o21ai_1
X_8289_ _8289_/Y _8289_/A _8299_/B VPWR VGND sg13g2_nand2_1
XFILLER_19_728 VPWR VGND sg13g2_decap_4
XFILLER_73_344 VPWR VGND sg13g2_decap_8
XFILLER_37_75 VPWR VGND sg13g2_decap_4
XFILLER_34_709 VPWR VGND sg13g2_decap_4
XFILLER_61_539 VPWR VGND sg13g2_decap_4
XFILLER_26_271 VPWR VGND sg13g2_decap_8
XFILLER_53_41 VPWR VGND sg13g2_fill_2
XFILLER_42_753 VPWR VGND sg13g2_decap_8
XFILLER_41_252 VPWR VGND sg13g2_decap_8
XFILLER_41_274 VPWR VGND sg13g2_decap_4
XFILLER_10_694 VPWR VGND sg13g2_decap_8
XFILLER_115_508 VPWR VGND sg13g2_decap_4
XFILLER_6_676 VPWR VGND sg13g2_decap_8
XFILLER_6_698 VPWR VGND sg13g2_fill_1
XFILLER_45_7 VPWR VGND sg13g2_fill_2
XFILLER_69_617 VPWR VGND sg13g2_decap_8
XFILLER_69_606 VPWR VGND sg13g2_fill_2
XFILLER_123_596 VPWR VGND sg13g2_decap_8
XFILLER_123_574 VPWR VGND sg13g2_decap_4
XFILLER_69_628 VPWR VGND sg13g2_fill_1
XFILLER_110_235 VPWR VGND sg13g2_decap_4
XFILLER_83_108 VPWR VGND sg13g2_decap_8
XFILLER_76_160 VPWR VGND sg13g2_decap_8
XFILLER_49_374 VPWR VGND sg13g2_decap_4
XFILLER_49_352 VPWR VGND sg13g2_decap_8
XFILLER_76_171 VPWR VGND sg13g2_fill_2
X_5990_ _5990_/Y _8528_/C _8439_/A2 _5989_/Y VPWR VGND sg13g2_o21ai_1
X_4941_ _4941_/Y _4939_/Y _4937_/Y _4940_/Y VPWR VGND sg13g2_a21oi_1
X_7660_ _7661_/B _8805_/Q _7660_/A2 _7846_/A2 _8854_/Q VPWR VGND sg13g2_a22oi_1
X_4872_ _4872_/Y _4944_/A _9356_/Q VPWR VGND sg13g2_nand2b_1
XFILLER_32_230 VPWR VGND sg13g2_decap_8
X_6611_ _6611_/X _6661_/A _9569_/Q _6622_/C VPWR VGND sg13g2_or3_1
X_9330_ _9330_/Q _9409_/CLK _9330_/D place2393/X VPWR VGND sg13g2_dfrbpq_1
X_7591_ _7591_/Y _7801_/A _7591_/B _7591_/C _7591_/D VPWR VGND sg13g2_nor4_1
X_6542_ _6560_/B _9454_/Q _6545_/B _9694_/Q VPWR VGND sg13g2_nand3b_1
X_9261_ _9261_/Q _9409_/CLK _9261_/D place2404/X VPWR VGND sg13g2_dfrbpq_1
X_6473_ _6473_/Y _9077_/Q _6506_/B1 _6507_/B1 _9139_/Q VPWR VGND sg13g2_a22oi_1
XFILLER_9_481 VPWR VGND sg13g2_fill_1
XFILLER_106_519 VPWR VGND sg13g2_decap_4
X_8212_ _9106_/D _8226_/A1 _8083_/Y _8211_/Y VPWR VGND sg13g2_o21ai_1
X_5424_ _5425_/A _5418_/Y _5423_/X _8697_/Q _5422_/Y VPWR VGND sg13g2_a22oi_1
X_9192_ _9192_/Q clkload8/A _9192_/D place2473/X VPWR VGND sg13g2_dfrbpq_1
X_8143_ _8143_/Y _8143_/A _8157_/B VPWR VGND sg13g2_nand2_1
X_5355_ _8795_/D _5366_/A _5366_/B _5355_/C _5366_/D VPWR VGND sg13g2_nor4_1
XFILLER_0_808 VPWR VGND sg13g2_fill_1
X_4306_ _4347_/B _8715_/Q VPWR VGND sg13g2_inv_1
XFILLER_102_736 VPWR VGND sg13g2_fill_1
X_8074_ _8074_/Y _8389_/C _9491_/Q _8498_/D _8083_/D VPWR VGND sg13g2_nand4_1
X_5286_ _5287_/B _5334_/A _5286_/B _5291_/D _9881_/A VPWR VGND sg13g2_nand4_1
XFILLER_102_758 VPWR VGND sg13g2_decap_8
X_7025_ _8279_/B _7025_/A _7025_/B VPWR VGND sg13g2_nor2_1
XFILLER_87_458 VPWR VGND sg13g2_decap_8
XFILLER_114_47 VPWR VGND sg13g2_decap_4
X_8976_ _8976_/Q _9199_/CLK _8976_/D place2424/X VPWR VGND sg13g2_dfrbpq_1
XFILLER_71_804 VPWR VGND sg13g2_fill_1
X_7927_ _7927_/Y _7946_/A _8976_/Q _8092_/A VPWR VGND sg13g2_nand3_1
XFILLER_82_174 VPWR VGND sg13g2_fill_1
XFILLER_43_528 VPWR VGND sg13g2_decap_4
X_7858_ _8935_/D _8935_/Q _7396_/Y _7885_/S VPWR VGND sg13g2_mux2_1
XFILLER_23_241 VPWR VGND sg13g2_fill_1
X_6809_ _9557_/D _9590_/Q _9557_/Q _6839_/S VPWR VGND sg13g2_mux2_1
XFILLER_11_414 VPWR VGND sg13g2_decap_8
X_7789_ _7791_/D _9272_/Q _5380_/Y _7846_/B1 _7789_/B2 VPWR VGND sg13g2_a22oi_1
X_9528_ _9528_/Q _9567_/CLK _9528_/D _9528_/RESET_B VPWR VGND sg13g2_dfrbpq_1
X_9459_ _9459_/Q _9662_/CLK _9459_/D place2445/X VPWR VGND sg13g2_dfrbpq_1
XFILLER_2_134 VPWR VGND sg13g2_fill_2
XFILLER_105_596 VPWR VGND sg13g2_decap_4
XFILLER_120_577 VPWR VGND sg13g2_decap_8
XFILLER_86_480 VPWR VGND sg13g2_decap_8
XFILLER_19_525 VPWR VGND sg13g2_decap_8
XFILLER_104_80 VPWR VGND sg13g2_decap_8
XFILLER_64_51 VPWR VGND sg13g2_decap_8
XFILLER_9_35 VPWR VGND sg13g2_decap_8
XFILLER_15_786 VPWR VGND sg13g2_decap_8
Xclkbuf_2_2__f_jtag_tck_i_regs clkbuf_leaf_9_jtag_tck_i_regs/A clkbuf_0_jtag_tck_i_regs/X
+ VPWR VGND sg13g2_buf_8
Xplace2308 _5132_/A _5187_/A VPWR VGND sg13g2_buf_1
Xplace2319 _6071_/A _9253_/Q VPWR VGND sg13g2_buf_1
XFILLER_10_491 VPWR VGND sg13g2_decap_8
XFILLER_97_701 VPWR VGND sg13g2_fill_2
XFILLER_123_371 VPWR VGND sg13g2_decap_8
XFILLER_97_723 VPWR VGND sg13g2_decap_4
X_5140_ _7897_/D _8355_/C _9475_/Q VPWR VGND sg13g2_and2_1
X_5071_ _7519_/D _8750_/Q _8520_/C _7775_/D VPWR VGND sg13g2_nor3_1
XFILLER_69_447 VPWR VGND sg13g2_decap_4
XFILLER_111_577 VPWR VGND sg13g2_fill_1
XFILLER_96_299 VPWR VGND sg13g2_fill_2
XFILLER_49_171 VPWR VGND sg13g2_fill_1
X_8830_ _8830_/Q _9620_/CLK _8830_/D place2428/X VPWR VGND sg13g2_dfrbpq_1
XFILLER_37_344 VPWR VGND sg13g2_fill_2
X_5973_ _9326_/D _5978_/B _5971_/Y _5972_/Y VPWR VGND sg13g2_o21ai_1
X_8761_ _9867_/A _9252_/CLK _8761_/D place2390/X VPWR VGND sg13g2_dfrbpq_1
XFILLER_52_314 VPWR VGND sg13g2_fill_1
XFILLER_18_580 VPWR VGND sg13g2_decap_8
X_7712_ _7712_/X _8856_/Q _8887_/Q _7831_/A VPWR VGND sg13g2_mux2_1
XFILLER_52_358 VPWR VGND sg13g2_fill_2
XFILLER_52_347 VPWR VGND sg13g2_fill_2
XFILLER_52_336 VPWR VGND sg13g2_decap_8
X_4924_ _4924_/Y _4924_/A _4924_/B _4924_/C VPWR VGND sg13g2_nand3_1
X_8692_ _8692_/Q _9630_/CLK _8692_/D fanout955/X VPWR VGND sg13g2_dfrbpq_1
XFILLER_21_723 VPWR VGND sg13g2_decap_8
XFILLER_33_550 VPWR VGND sg13g2_decap_8
X_7643_ _7647_/B _7651_/A _9010_/Q _7650_/C VPWR VGND sg13g2_nor3_1
X_4855_ _4855_/Y _4855_/A _9354_/Q VPWR VGND sg13g2_nor2b_1
X_7574_ _7575_/B _7574_/A _7574_/B _7574_/C _7574_/D VPWR VGND sg13g2_and4_1
X_4786_ _4786_/Y _4784_/Y _4785_/Y _4864_/A1 VPWR VGND sg13g2_a21oi_1
XFILLER_119_644 VPWR VGND sg13g2_decap_8
XFILLER_118_132 VPWR VGND sg13g2_decap_8
X_9313_ _9313_/Q _9410_/CLK _9313_/D place2406/X VPWR VGND sg13g2_dfrbpq_1
XFILLER_109_14 VPWR VGND sg13g2_fill_2
X_6525_ _6525_/X _7775_/A _9267_/Q _7519_/C _7519_/D VPWR VGND sg13g2_and4_1
XFILLER_118_165 VPWR VGND sg13g2_decap_4
XFILLER_109_25 VPWR VGND sg13g2_decap_4
XFILLER_107_806 VPWR VGND sg13g2_fill_2
X_9244_ _9244_/Q clkload4/A _9244_/D place2480/X VPWR VGND sg13g2_dfrbpq_1
XFILLER_106_327 VPWR VGND sg13g2_decap_4
X_6456_ _6456_/Y _8886_/Q _6462_/A2 _6453_/Y _6170_/Y _6455_/Y VPWR VGND sg13g2_a221oi_1
X_5407_ _5407_/Y _5395_/Y _5406_/Y _6959_/B VPWR VGND sg13g2_o21ai_1
X_6387_ _6387_/Y _6415_/A1 _6470_/A2 _6387_/B1 VPWR VGND sg13g2_a21oi_1
X_9175_ _9175_/Q _9501_/CLK _9175_/D place2468/X VPWR VGND sg13g2_dfrbpq_1
X_5338_ _5338_/Y _5338_/A _9889_/A VPWR VGND sg13g2_nand2_1
XFILLER_0_616 VPWR VGND sg13g2_decap_8
XFILLER_0_627 VPWR VGND sg13g2_fill_1
X_8126_ _9063_/D _8130_/A1 _8050_/Y _8125_/Y VPWR VGND sg13g2_o21ai_1
XFILLER_102_533 VPWR VGND sg13g2_fill_2
X_8057_ _9034_/D _5343_/Y _8056_/Y _8055_/Y VPWR VGND sg13g2_o21ai_1
X_7008_ _7008_/Y _8092_/A _9502_/Q _7951_/C VPWR VGND sg13g2_nand3_1
X_5269_ _8772_/D _5269_/A1 _5364_/C _5268_/Y VPWR VGND sg13g2_o21ai_1
XFILLER_18_99 VPWR VGND sg13g2_decap_8
X_8959_ _8959_/Q _9242_/CLK _8959_/D place2499/X VPWR VGND sg13g2_dfrbpq_1
XFILLER_71_689 VPWR VGND sg13g2_decap_4
XFILLER_31_509 VPWR VGND sg13g2_fill_2
XFILLER_43_369 VPWR VGND sg13g2_decap_8
XFILLER_51_391 VPWR VGND sg13g2_decap_8
XFILLER_8_716 VPWR VGND sg13g2_fill_2
XFILLER_12_767 VPWR VGND sg13g2_decap_8
XFILLER_119_0 VPWR VGND sg13g2_decap_8
XFILLER_98_509 VPWR VGND sg13g2_fill_1
XFILLER_112_308 VPWR VGND sg13g2_decap_4
XFILLER_1_0 VPWR VGND sg13g2_decap_8
XFILLER_105_393 VPWR VGND sg13g2_fill_2
XFILLER_78_233 VPWR VGND sg13g2_decap_4
XFILLER_59_84 VPWR VGND sg13g2_fill_2
XFILLER_59_73 VPWR VGND sg13g2_decap_8
XFILLER_79_778 VPWR VGND sg13g2_decap_4
XFILLER_78_288 VPWR VGND sg13g2_fill_1
XFILLER_66_439 VPWR VGND sg13g2_fill_1
XFILLER_59_480 VPWR VGND sg13g2_decap_8
XFILLER_93_269 VPWR VGND sg13g2_decap_8
XFILLER_35_804 VPWR VGND sg13g2_fill_1
XFILLER_75_94 VPWR VGND sg13g2_decap_4
XFILLER_34_303 VPWR VGND sg13g2_fill_1
XFILLER_61_111 VPWR VGND sg13g2_decap_8
XFILLER_61_155 VPWR VGND sg13g2_decap_8
XFILLER_61_188 VPWR VGND sg13g2_fill_2
XFILLER_15_594 VPWR VGND sg13g2_decap_8
X_4640_ _8718_/D _4640_/A _4640_/B _4640_/C _4640_/D VPWR VGND sg13g2_nand4_1
Xplace2127 _8439_/A2 _5370_/C VPWR VGND sg13g2_buf_1
X_6310_ _6310_/X _8987_/Q _9049_/Q _9111_/Q _9173_/Q _6514_/S0 _6514_/S1 VPWR VGND
+ sg13g2_mux4_1
Xplace2116 _8039_/C _7032_/D VPWR VGND sg13g2_buf_1
Xplace2105 _7719_/B _7725_/B VPWR VGND sg13g2_buf_1
X_4571_ _4571_/Y _4571_/A hold3053/X VPWR VGND sg13g2_nor2b_1
XFILLER_116_636 VPWR VGND sg13g2_decap_8
XFILLER_115_124 VPWR VGND sg13g2_fill_2
Xplace2138 _5147_/D _8530_/A VPWR VGND sg13g2_buf_1
Xplace2149 _4934_/B _4972_/B VPWR VGND sg13g2_buf_1
X_7290_ _7294_/A _7425_/C _9116_/Q _7295_/C VPWR VGND sg13g2_nor3_1
XFILLER_89_509 VPWR VGND sg13g2_decap_8
X_6241_ _6241_/Y _6325_/A1 _6240_/Y _6229_/B VPWR VGND sg13g2_o21ai_1
XFILLER_69_200 VPWR VGND sg13g2_fill_1
X_6172_ _6173_/D _6224_/A _9234_/Q _6247_/C _6369_/D VPWR VGND sg13g2_nand4_1
X_5123_ _5146_/D _5123_/A _5123_/B _9262_/Q VPWR VGND sg13g2_nand3_1
X_5054_ _5055_/D _9858_/A _9859_/A _5049_/Y _5096_/C _5041_/Y VPWR VGND sg13g2_a221oi_1
XFILLER_85_737 VPWR VGND sg13g2_decap_8
X_9862_ _9862_/X _9862_/A VPWR VGND sg13g2_buf_1
X_8813_ _8813_/Q _9219_/CLK _8813_/D place2402/X VPWR VGND sg13g2_dfrbpq_1
XFILLER_53_612 VPWR VGND sg13g2_decap_4
XFILLER_25_336 VPWR VGND sg13g2_decap_4
X_5956_ _5956_/Y _9486_/Q _5980_/A2 _5955_/Y VPWR VGND sg13g2_a21oi_1
X_8744_ _8744_/Q _9675_/CLK _8744_/D place2444/X VPWR VGND sg13g2_dfrbpq_1
XFILLER_40_306 VPWR VGND sg13g2_fill_2
X_5887_ _9312_/D _9312_/Q _5920_/B _5886_/Y VPWR VGND sg13g2_a21o_1
XFILLER_52_199 VPWR VGND sg13g2_decap_4
X_8675_ _8675_/Q _8678_/CLK _8675_/D fanout944/X VPWR VGND sg13g2_dfrbpq_1
X_4907_ _4907_/Y _4944_/A _9360_/Q VPWR VGND sg13g2_nand2b_1
X_7626_ _7626_/Y _9133_/Q _7775_/C _7625_/Y VPWR VGND sg13g2_o21ai_1
X_4838_ _4838_/Y _4855_/A _9351_/Q VPWR VGND sg13g2_nand2b_1
XFILLER_21_542 VPWR VGND sg13g2_decap_8
X_7557_ _7560_/A _9290_/Q _7557_/A2 _7557_/B1 _9322_/Q VPWR VGND sg13g2_a22oi_1
X_4769_ _4769_/Y _4757_/Y _4768_/Y _4864_/A1 VPWR VGND sg13g2_a21oi_1
X_7488_ _7489_/D _9033_/Q _7491_/B _7486_/X VPWR VGND sg13g2_o21ai_1
X_6508_ _6508_/Y _6506_/Y _6507_/Y _6455_/A VPWR VGND sg13g2_a21oi_1
XFILLER_107_669 VPWR VGND sg13g2_decap_8
XFILLER_106_146 VPWR VGND sg13g2_decap_8
X_6439_ _6439_/Y _6176_/A _6438_/X _6367_/Y VPWR VGND sg13g2_a21oi_1
X_9227_ _9227_/Q clkload7/A _9227_/D place2462/X VPWR VGND sg13g2_dfrbpq_1
Xplace1971 _7796_/A2 _7843_/A2 VPWR VGND sg13g2_buf_1
Xplace1982 _5591_/B _5600_/B VPWR VGND sg13g2_buf_1
Xplace1960 _6430_/B2 _6042_/Y VPWR VGND sg13g2_buf_1
X_9158_ _9158_/Q _9188_/CLK _9158_/D place2475/X VPWR VGND sg13g2_dfrbpq_1
Xplace1993 _7551_/B _5387_/B VPWR VGND sg13g2_buf_1
XFILLER_0_424 VPWR VGND sg13g2_decap_8
X_8109_ _8109_/Y _8109_/A _8163_/B VPWR VGND sg13g2_nand2_1
XFILLER_88_564 VPWR VGND sg13g2_decap_4
X_9089_ _9089_/Q _9183_/CLK _9089_/D place2472/X VPWR VGND sg13g2_dfrbpq_1
XFILLER_75_236 VPWR VGND sg13g2_fill_2
XFILLER_29_98 VPWR VGND sg13g2_decap_8
XFILLER_28_141 VPWR VGND sg13g2_decap_8
XFILLER_29_642 VPWR VGND sg13g2_fill_1
XFILLER_56_483 VPWR VGND sg13g2_decap_8
XFILLER_32_807 VPWR VGND sg13g2_fill_2
XFILLER_71_453 VPWR VGND sg13g2_decap_8
XFILLER_61_41 VPWR VGND sg13g2_fill_1
Xinput2561 _7825_/B2 hartinfo_i[29] VPWR VGND sg13g2_buf_1
Xinput2550 _7633_/B2 hartinfo_i[19] VPWR VGND sg13g2_buf_1
Xinput2594 _5983_/A master_rdata_i[24] VPWR VGND sg13g2_buf_1
Xinput2583 _5945_/B master_rdata_i[14] VPWR VGND sg13g2_buf_1
Xinput2572 _5423_/B jtag_tdi_i VPWR VGND sg13g2_buf_1
XFILLER_8_579 VPWR VGND sg13g2_decap_8
XFILLER_6_14 VPWR VGND sg13g2_decap_8
XFILLER_113_606 VPWR VGND sg13g2_decap_8
XFILLER_3_251 VPWR VGND sg13g2_decap_8
XFILLER_39_417 VPWR VGND sg13g2_fill_2
XFILLER_79_597 VPWR VGND sg13g2_fill_1
XFILLER_19_130 VPWR VGND sg13g2_decap_8
XFILLER_94_589 VPWR VGND sg13g2_decap_8
XFILLER_62_442 VPWR VGND sg13g2_fill_1
XFILLER_47_494 VPWR VGND sg13g2_decap_4
XFILLER_19_185 VPWR VGND sg13g2_decap_8
XFILLER_90_762 VPWR VGND sg13g2_decap_8
X_5810_ _5811_/A _9298_/Q _8585_/A2 _8585_/B1 _9495_/Q VPWR VGND sg13g2_a22oi_1
X_6790_ _6790_/Y _9670_/Q _9675_/Q _9673_/Q _9672_/Q VPWR VGND sg13g2_nor4_1
XFILLER_62_475 VPWR VGND sg13g2_fill_2
X_5741_ _5741_/Y _9322_/Q _5765_/B VPWR VGND sg13g2_nand2b_1
XFILLER_34_177 VPWR VGND sg13g2_decap_4
X_8460_ _8460_/Y _8470_/A _9235_/Q _8474_/C VPWR VGND sg13g2_nand3_1
X_5672_ _8604_/D _5672_/A VPWR VGND sg13g2_inv_1
X_7411_ _7412_/D _9153_/Q _7411_/B VPWR VGND sg13g2_nor2_1
X_4623_ _6692_/A _4675_/A _9456_/Q _9455_/Q VPWR VGND sg13g2_nand3b_1
XFILLER_30_394 VPWR VGND sg13g2_decap_8
X_8391_ _8391_/Y _8409_/A _9196_/Q _8391_/C VPWR VGND sg13g2_nand3_1
X_4554_ _4554_/Y _4554_/A _4554_/B _4554_/C _5827_/A VPWR VGND sg13g2_nand4_1
X_7342_ _7342_/Y _7341_/Y _7336_/Y _7459_/A VPWR VGND sg13g2_a21oi_1
XFILLER_116_444 VPWR VGND sg13g2_decap_8
XFILLER_116_433 VPWR VGND sg13g2_fill_1
X_7273_ _7275_/D _9146_/Q _7291_/B VPWR VGND sg13g2_nor2_1
X_4485_ _6953_/S _8706_/Q _9640_/Q VPWR VGND sg13g2_nand2b_1
X_9012_ _9012_/Q _9198_/CLK _9012_/D place2437/X VPWR VGND sg13g2_dfrbpq_1
X_6224_ _6248_/C _6224_/A _6333_/C VPWR VGND sg13g2_nor2_1
XFILLER_112_661 VPWR VGND sg13g2_decap_8
XFILLER_58_704 VPWR VGND sg13g2_fill_2
X_6155_ _6155_/Y _8842_/Q _7176_/B2 _6516_/B _6154_/Y _6152_/Y VPWR VGND sg13g2_a221oi_1
XFILLER_112_683 VPWR VGND sg13g2_fill_1
XFILLER_111_171 VPWR VGND sg13g2_fill_1
X_5106_ _5346_/C _8061_/A _9473_/Q VPWR VGND sg13g2_nand2_1
XFILLER_58_748 VPWR VGND sg13g2_fill_2
X_6086_ _6086_/Y _8836_/Q _6958_/C _6085_/X _6129_/A VPWR VGND sg13g2_a22oi_1
XFILLER_122_14 VPWR VGND sg13g2_decap_8
X_5037_ _5126_/B _6534_/B _5070_/C _9410_/Q VPWR VGND sg13g2_a21oi_1
XFILLER_13_306 VPWR VGND sg13g2_decap_4
X_6988_ _6992_/B _7690_/A _8826_/Q _7747_/C VPWR VGND sg13g2_nor3_1
X_8727_ _8727_/Q _9672_/CLK _8738_/Q place2440/X VPWR VGND sg13g2_dfrbpq_1
XFILLER_41_648 VPWR VGND sg13g2_fill_1
X_5939_ _5939_/Y _5939_/A _8530_/D _8534_/A VPWR VGND sg13g2_nand3_1
X_8658_ _8658_/Q _9511_/CLK _8658_/D fanout957/X VPWR VGND sg13g2_dfrbpq_1
X_7609_ _7611_/C _7718_/A _9008_/Q _7723_/C VPWR VGND sg13g2_nor3_1
X_8589_ _8818_/D _8589_/A VPWR VGND sg13g2_buf_1
XFILLER_21_383 VPWR VGND sg13g2_decap_8
XFILLER_119_260 VPWR VGND sg13g2_decap_4
XFILLER_5_527 VPWR VGND sg13g2_fill_1
XFILLER_5_516 VPWR VGND sg13g2_decap_8
Xplace2480 place2480/X place2481/X VPWR VGND sg13g2_buf_1
Xplace2491 place2491/X place2507/X VPWR VGND sg13g2_buf_1
Xplace1790 _8585_/B1 _5787_/Y VPWR VGND sg13g2_buf_1
Xhold3160 _8117_/A _9059_/Q VPWR VGND sg13g2_dlygate4sd3_1
XFILLER_102_160 VPWR VGND sg13g2_fill_1
Xhold3193 _8335_/A _9168_/Q VPWR VGND sg13g2_dlygate4sd3_1
Xhold3171 _8171_/A _9086_/Q VPWR VGND sg13g2_dlygate4sd3_1
Xhold3182 _5632_/B2 _8619_/Q VPWR VGND sg13g2_dlygate4sd3_1
XFILLER_64_718 VPWR VGND sg13g2_decap_8
XFILLER_36_409 VPWR VGND sg13g2_fill_2
XFILLER_91_526 VPWR VGND sg13g2_fill_1
XFILLER_76_589 VPWR VGND sg13g2_decap_8
XFILLER_29_461 VPWR VGND sg13g2_fill_2
XFILLER_16_100 VPWR VGND sg13g2_fill_2
XFILLER_72_62 VPWR VGND sg13g2_fill_1
XFILLER_71_294 VPWR VGND sg13g2_decap_8
XFILLER_32_637 VPWR VGND sg13g2_decap_4
XFILLER_12_394 VPWR VGND sg13g2_decap_8
XFILLER_8_376 VPWR VGND sg13g2_decap_8
Xoutput2717 master_wdata_o[27] _5776_/X VPWR VGND sg13g2_buf_1
Xoutput2706 master_wdata_o[17] _5748_/Y VPWR VGND sg13g2_buf_1
Xoutput2728 master_wdata_o[8] _5719_/Y VPWR VGND sg13g2_buf_1
Xoutput2739 slave_rdata_o[16] _4917_/Y VPWR VGND sg13g2_buf_1
XFILLER_98_125 VPWR VGND sg13g2_fill_2
XFILLER_4_571 VPWR VGND sg13g2_fill_2
XFILLER_98_158 VPWR VGND sg13g2_fill_2
XFILLER_79_383 VPWR VGND sg13g2_decap_8
XFILLER_67_534 VPWR VGND sg13g2_decap_8
XFILLER_39_236 VPWR VGND sg13g2_decap_8
XFILLER_39_258 VPWR VGND sg13g2_decap_8
XFILLER_82_504 VPWR VGND sg13g2_fill_1
XFILLER_67_589 VPWR VGND sg13g2_fill_2
X_7960_ _8990_/D _5344_/C _7979_/A _7959_/Y VPWR VGND sg13g2_o21ai_1
X_6911_ _6912_/C _8739_/D _8503_/B VPWR VGND sg13g2_nor2b_1
X_7891_ _7891_/Y _7899_/A _8961_/Q _8353_/C VPWR VGND sg13g2_nand3_1
X_6842_ _8500_/C _8722_/Q _9622_/Q VPWR VGND sg13g2_xor2_1
XFILLER_63_762 VPWR VGND sg13g2_decap_4
X_9630_ _9630_/Q _9630_/CLK _9630_/D fanout951/X VPWR VGND sg13g2_dfrbpq_1
XFILLER_35_464 VPWR VGND sg13g2_fill_1
XFILLER_63_795 VPWR VGND sg13g2_fill_2
X_6773_ _9532_/D _9532_/Q _9442_/Q _6779_/S VPWR VGND sg13g2_mux2_1
X_9561_ _9561_/Q _9587_/CLK _9561_/D _9561_/RESET_B VPWR VGND sg13g2_dfrbpq_1
X_9492_ _9492_/Q _9621_/CLK _9492_/D _9492_/RESET_B VPWR VGND sg13g2_dfrbpq_1
X_5724_ _5724_/Y _5736_/A _9316_/Q VPWR VGND sg13g2_nand2_1
X_8512_ _9257_/D _8500_/B _8511_/Y _8509_/Y VPWR VGND sg13g2_o21ai_1
X_8443_ _9226_/D _8444_/A _5372_/C _8442_/Y VPWR VGND sg13g2_o21ai_1
X_5655_ _5655_/Y _5625_/B _4457_/X _5627_/X _9454_/Q VPWR VGND sg13g2_a22oi_1
XFILLER_108_208 VPWR VGND sg13g2_fill_1
X_4606_ _8740_/D _4606_/A _4606_/B _4606_/C _4606_/D VPWR VGND sg13g2_nand4_1
X_8374_ _9187_/D _5355_/C _8409_/A _8373_/Y VPWR VGND sg13g2_o21ai_1
XFILLER_117_731 VPWR VGND sg13g2_decap_8
X_5586_ _5586_/Y _9448_/Q _5579_/B _5586_/B1 _8650_/Q VPWR VGND sg13g2_a22oi_1
X_7325_ _8899_/D _8899_/Q _7324_/Y _7848_/S VPWR VGND sg13g2_mux2_1
XFILLER_117_786 VPWR VGND sg13g2_fill_1
XFILLER_89_103 VPWR VGND sg13g2_decap_8
X_4537_ _7244_/D _9465_/Q _9466_/Q VPWR VGND sg13g2_nand2b_1
XFILLER_116_285 VPWR VGND sg13g2_fill_1
X_7256_ _7258_/C _7278_/C _7297_/B _9083_/Q VPWR VGND sg13g2_nor3_1
X_4468_ _9679_/D _4729_/A _4468_/B VPWR VGND sg13g2_nor2_1
XFILLER_89_147 VPWR VGND sg13g2_decap_8
X_6207_ _6207_/X _8975_/Q _9037_/Q _9099_/Q _9161_/Q _6421_/S0 _6421_/S1 VPWR VGND
+ sg13g2_mux4_1
X_7187_ _7187_/Y _7187_/A _7187_/B _7236_/C _7187_/D VPWR VGND sg13g2_nand4_1
X_6138_ _6138_/Y _8840_/Q _6375_/A2 _6129_/A _6137_/X _6136_/Y VPWR VGND sg13g2_a221oi_1
X_4399_ _8672_/D _4399_/A _5438_/B_N VPWR VGND sg13g2_nor2b_1
XFILLER_112_491 VPWR VGND sg13g2_fill_1
XFILLER_73_515 VPWR VGND sg13g2_fill_1
XFILLER_73_504 VPWR VGND sg13g2_fill_2
X_6069_ _6069_/Y _6373_/A1 _6373_/A2 _6069_/B1 VPWR VGND sg13g2_a21oi_1
XFILLER_45_206 VPWR VGND sg13g2_decap_8
XFILLER_26_420 VPWR VGND sg13g2_fill_2
XFILLER_13_158 VPWR VGND sg13g2_decap_8
XFILLER_41_456 VPWR VGND sg13g2_fill_2
XFILLER_42_21 VPWR VGND sg13g2_fill_1
Xclkbuf_3_3__f_clk_i clkload1/A clkbuf_0_clk_i/X VPWR VGND sg13g2_buf_8
XFILLER_5_324 VPWR VGND sg13g2_decap_8
XFILLER_107_263 VPWR VGND sg13g2_fill_1
XFILLER_107_274 VPWR VGND sg13g2_decap_4
XFILLER_123_789 VPWR VGND sg13g2_decap_8
XFILLER_103_480 VPWR VGND sg13g2_fill_2
XFILLER_49_567 VPWR VGND sg13g2_decap_8
XFILLER_17_431 VPWR VGND sg13g2_decap_4
XFILLER_36_228 VPWR VGND sg13g2_fill_1
XFILLER_83_61 VPWR VGND sg13g2_decap_4
XFILLER_17_442 VPWR VGND sg13g2_decap_4
XFILLER_20_629 VPWR VGND sg13g2_decap_8
XFILLER_9_674 VPWR VGND sg13g2_fill_2
X_5440_ _8678_/D _5440_/A _5454_/B_N VPWR VGND sg13g2_nor2b_1
X_5371_ _8811_/D _7028_/C _5836_/C _5371_/C _5372_/D VPWR VGND sg13g2_nor4_1
X_4322_ _5242_/A _9874_/A VPWR VGND sg13g2_inv_1
X_8090_ _9046_/D _8098_/A1 _8089_/Y _8088_/Y VPWR VGND sg13g2_o21ai_1
X_7110_ _8856_/D _7109_/Y _8856_/Q _7110_/S VPWR VGND sg13g2_mux2_1
XFILLER_114_767 VPWR VGND sg13g2_fill_1
X_7041_ _7041_/Y _7050_/A _8834_/Q VPWR VGND sg13g2_nand2_1
XFILLER_113_277 VPWR VGND sg13g2_decap_8
XFILLER_86_117 VPWR VGND sg13g2_decap_8
XFILLER_83_802 VPWR VGND sg13g2_fill_2
X_8992_ _8992_/Q _9242_/CLK _8992_/D place2482/X VPWR VGND sg13g2_dfrbpq_1
XFILLER_82_334 VPWR VGND sg13g2_fill_2
X_7943_ _8983_/D _5368_/C _7948_/A _7942_/Y VPWR VGND sg13g2_o21ai_1
XFILLER_36_740 VPWR VGND sg13g2_decap_8
X_7874_ _8947_/D _8947_/Q _7637_/Y _7881_/S VPWR VGND sg13g2_mux2_1
XFILLER_35_250 VPWR VGND sg13g2_decap_8
X_6825_ _9573_/D _9606_/Q _9573_/Q _6840_/S VPWR VGND sg13g2_mux2_1
X_9613_ _9613_/Q _9621_/CLK _9613_/D _9613_/RESET_B VPWR VGND sg13g2_dfrbpq_1
X_9544_ _9544_/Q _9645_/CLK _9544_/D _9544_/RESET_B VPWR VGND sg13g2_dfrbpq_1
X_6756_ _9515_/D _9515_/Q _9425_/Q _6756_/S VPWR VGND sg13g2_mux2_1
XFILLER_51_787 VPWR VGND sg13g2_fill_2
XFILLER_51_776 VPWR VGND sg13g2_fill_2
X_5707_ _5708_/B _9677_/Q _9678_/Q VPWR VGND sg13g2_or2_1
X_6687_ _9460_/D _6686_/B _6685_/Y _6686_/Y VPWR VGND sg13g2_a21oi_1
X_9475_ _9475_/Q clkload6/A _9475_/D _9475_/RESET_B VPWR VGND sg13g2_dfrbpq_1
X_8426_ _8426_/Y _8428_/A _9217_/Q _8426_/C VPWR VGND sg13g2_nand3_1
X_5638_ _5640_/A _8613_/Q _5660_/B VPWR VGND sg13g2_nor2_1
X_5569_ _8644_/D _5568_/Y _5567_/Y _5581_/B1 VPWR VGND sg13g2_a21oi_1
X_8357_ _8357_/Y _8367_/A _9179_/Q _8365_/C VPWR VGND sg13g2_nand3_1
X_7308_ _7322_/C _7831_/A _8867_/Q _7831_/C VPWR VGND sg13g2_nand3_1
XFILLER_5_7 VPWR VGND sg13g2_decap_8
X_8288_ _9144_/D _8288_/A1 _7957_/Y _8287_/Y VPWR VGND sg13g2_o21ai_1
XFILLER_120_715 VPWR VGND sg13g2_fill_2
XFILLER_105_789 VPWR VGND sg13g2_fill_1
X_7239_ _8894_/D _7238_/Y _8894_/Q _7239_/S VPWR VGND sg13g2_mux2_1
XFILLER_104_299 VPWR VGND sg13g2_fill_1
XFILLER_37_32 VPWR VGND sg13g2_fill_1
XFILLER_73_323 VPWR VGND sg13g2_fill_2
XFILLER_46_559 VPWR VGND sg13g2_fill_2
XFILLER_37_87 VPWR VGND sg13g2_fill_1
XFILLER_54_570 VPWR VGND sg13g2_fill_1
XFILLER_26_250 VPWR VGND sg13g2_decap_8
XFILLER_27_784 VPWR VGND sg13g2_fill_2
XFILLER_27_795 VPWR VGND sg13g2_fill_2
XFILLER_42_732 VPWR VGND sg13g2_decap_8
XFILLER_53_97 VPWR VGND sg13g2_decap_8
X_9503__2877 _9503_/RESET_B VPWR VGND sg13g2_tiehi
XFILLER_41_286 VPWR VGND sg13g2_fill_2
XFILLER_108_583 VPWR VGND sg13g2_fill_2
XFILLER_123_553 VPWR VGND sg13g2_decap_8
XFILLER_111_715 VPWR VGND sg13g2_fill_1
XFILLER_96_437 VPWR VGND sg13g2_fill_1
XFILLER_68_106 VPWR VGND sg13g2_decap_8
XFILLER_38_7 VPWR VGND sg13g2_decap_8
XFILLER_49_320 VPWR VGND sg13g2_fill_1
XFILLER_92_610 VPWR VGND sg13g2_decap_8
XFILLER_65_802 VPWR VGND sg13g2_fill_2
XFILLER_92_643 VPWR VGND sg13g2_decap_8
XFILLER_77_695 VPWR VGND sg13g2_decap_4
XFILLER_64_356 VPWR VGND sg13g2_decap_4
XFILLER_18_795 VPWR VGND sg13g2_fill_1
X_4940_ _4940_/Y _5008_/A _9364_/Q VPWR VGND sg13g2_nor2b_1
X_4871_ _4871_/Y _4783_/B _4868_/Y _4870_/Y VPWR VGND sg13g2_o21ai_1
Xclkbuf_leaf_11_jtag_tck_i_regs _9582_/CLK clkload26/A VPWR VGND sg13g2_buf_16
X_6610_ _6610_/Y _6610_/A _6654_/B VPWR VGND sg13g2_nand2_1
X_7590_ _7591_/D _9038_/Q _7767_/B _7589_/Y VPWR VGND sg13g2_o21ai_1
XFILLER_60_584 VPWR VGND sg13g2_decap_8
XFILLER_60_562 VPWR VGND sg13g2_decap_8
XFILLER_32_242 VPWR VGND sg13g2_decap_8
XFILLER_32_264 VPWR VGND sg13g2_decap_8
XFILLER_119_804 VPWR VGND sg13g2_fill_1
X_6541_ _6558_/A _6541_/A _6541_/B _6561_/B _6545_/D VPWR VGND sg13g2_nand4_1
XFILLER_20_459 VPWR VGND sg13g2_decap_8
X_9260_ _9260_/Q _9260_/CLK _9260_/D place2404/X VPWR VGND sg13g2_dfrbpq_1
X_6472_ _6472_/Y _9015_/Q _6506_/A2 _6507_/A2 _9201_/Q VPWR VGND sg13g2_a22oi_1
X_8211_ _8211_/Y _8211_/A _8219_/B VPWR VGND sg13g2_nand2_1
X_9191_ _9191_/Q clkload7/A _9191_/D place2457/X VPWR VGND sg13g2_dfrbpq_1
X_5423_ _5423_/X _9695_/Q _5423_/B VPWR VGND sg13g2_and2_1
X_8142_ _9071_/D _8156_/A1 _8071_/Y _8141_/Y VPWR VGND sg13g2_o21ai_1
X_5354_ _8794_/D _5360_/A _5360_/B _5354_/C _5360_/D VPWR VGND sg13g2_nor4_1
X_4305_ _8501_/A _9255_/Q VPWR VGND sg13g2_inv_1
XFILLER_114_586 VPWR VGND sg13g2_fill_2
XFILLER_102_715 VPWR VGND sg13g2_decap_8
XFILLER_99_264 VPWR VGND sg13g2_decap_8
X_5285_ _5313_/C _9881_/A _5291_/B _5291_/C _5291_/D VPWR VGND sg13g2_and4_1
X_8073_ _8073_/Y _8073_/A _8094_/B VPWR VGND sg13g2_nand2_1
X_7024_ _7025_/B _7028_/A _7028_/B _7024_/C _7024_/D VPWR VGND sg13g2_nor4_1
XFILLER_67_150 VPWR VGND sg13g2_decap_4
XFILLER_55_301 VPWR VGND sg13g2_decap_8
XFILLER_83_643 VPWR VGND sg13g2_decap_8
XFILLER_28_548 VPWR VGND sg13g2_fill_1
XFILLER_83_654 VPWR VGND sg13g2_fill_2
X_8975_ _8975_/Q _9501_/CLK _8975_/D place2470/X VPWR VGND sg13g2_dfrbpq_1
X_7926_ _8975_/D _5360_/C _7924_/A _7924_/Y VPWR VGND sg13g2_o21ai_1
XFILLER_43_518 VPWR VGND sg13g2_fill_2
XFILLER_90_18 VPWR VGND sg13g2_decap_4
X_7857_ _8934_/D _8934_/Q _7378_/Y _7885_/S VPWR VGND sg13g2_mux2_1
XFILLER_24_732 VPWR VGND sg13g2_decap_8
X_6808_ _9556_/D _9589_/Q _9556_/Q _6813_/S VPWR VGND sg13g2_mux2_1
XFILLER_24_765 VPWR VGND sg13g2_fill_1
XFILLER_24_776 VPWR VGND sg13g2_decap_8
X_7788_ _7788_/Y _9333_/Q _7826_/A2 _7788_/B1 _8860_/Q _7775_/Y VPWR VGND sg13g2_a221oi_1
XFILLER_11_448 VPWR VGND sg13g2_fill_2
X_9527_ _9527_/Q _9567_/CLK _9527_/D _9527_/RESET_B VPWR VGND sg13g2_dfrbpq_1
X_6739_ _6739_/Y _8718_/D _6745_/C VPWR VGND sg13g2_nor2_1
X_9458_ _9458_/Q _9649_/CLK _9458_/D fanout975/X VPWR VGND sg13g2_dfrbpq_1
XFILLER_23_89 VPWR VGND sg13g2_decap_8
X_8409_ _8409_/Y _8409_/A _9205_/Q _8409_/C VPWR VGND sg13g2_nand3_1
X_9389_ _9389_/Q clkload9/A _9389_/D place2505/X VPWR VGND sg13g2_dfrbpq_1
XFILLER_101_770 VPWR VGND sg13g2_fill_1
XFILLER_48_97 VPWR VGND sg13g2_fill_1
XFILLER_74_665 VPWR VGND sg13g2_decap_8
XFILLER_0_49 VPWR VGND sg13g2_decap_8
XFILLER_46_356 VPWR VGND sg13g2_decap_4
XFILLER_46_367 VPWR VGND sg13g2_decap_8
XFILLER_15_743 VPWR VGND sg13g2_decap_8
XFILLER_9_14 VPWR VGND sg13g2_decap_8
XFILLER_120_80 VPWR VGND sg13g2_fill_1
XFILLER_14_275 VPWR VGND sg13g2_decap_4
XFILLER_80_84 VPWR VGND sg13g2_fill_1
Xplace2309 _5187_/A _9260_/Q VPWR VGND sg13g2_buf_1
XFILLER_123_350 VPWR VGND sg13g2_decap_8
XFILLER_111_501 VPWR VGND sg13g2_fill_2
XFILLER_69_415 VPWR VGND sg13g2_fill_1
XFILLER_69_404 VPWR VGND sg13g2_decap_8
XFILLER_36_4 VPWR VGND sg13g2_fill_2
XFILLER_111_534 VPWR VGND sg13g2_fill_2
X_5070_ _5784_/D _6534_/A _6534_/B _5070_/C _8750_/Q VPWR VGND sg13g2_or4_1
XFILLER_96_267 VPWR VGND sg13g2_decap_4
XFILLER_56_109 VPWR VGND sg13g2_fill_1
XFILLER_49_183 VPWR VGND sg13g2_fill_2
XFILLER_37_323 VPWR VGND sg13g2_decap_8
XFILLER_64_131 VPWR VGND sg13g2_fill_1
XFILLER_37_367 VPWR VGND sg13g2_decap_8
X_5972_ _5972_/Y _9326_/Q _5978_/B VPWR VGND sg13g2_nand2_1
X_8760_ _9866_/A _9252_/CLK _8760_/D place2401/X VPWR VGND sg13g2_dfrbpq_1
XFILLER_37_378 VPWR VGND sg13g2_fill_2
X_7711_ _7714_/B _9220_/Q _8413_/B _7808_/B1 _8807_/Q VPWR VGND sg13g2_a22oi_1
XFILLER_80_657 VPWR VGND sg13g2_decap_8
X_4923_ _4924_/C _4923_/A _4945_/C VPWR VGND sg13g2_nand2_1
X_8691_ _8691_/Q _9630_/CLK _8691_/D fanout955/X VPWR VGND sg13g2_dfrbpq_1
X_7642_ _7656_/A _9294_/Q _7796_/A2 _7796_/B1 _9326_/Q _7641_/Y VPWR VGND sg13g2_a221oi_1
XFILLER_60_381 VPWR VGND sg13g2_decap_8
X_4854_ _4854_/Y _4883_/A _4854_/B _4854_/C VPWR VGND sg13g2_nor3_1
X_7573_ _7574_/D _8800_/Q _7301_/B _7680_/B1 _8880_/Q VPWR VGND sg13g2_a22oi_1
X_4785_ _4785_/Y _4983_/B _4903_/C _8818_/Q VPWR VGND sg13g2_nand3_1
XFILLER_20_245 VPWR VGND sg13g2_decap_8
XFILLER_118_111 VPWR VGND sg13g2_decap_8
XFILLER_118_100 VPWR VGND sg13g2_decap_4
X_9312_ _9312_/Q _9410_/CLK _9312_/D place2406/X VPWR VGND sg13g2_dfrbpq_1
X_6524_ _6524_/Y _6524_/A _8515_/C VPWR VGND sg13g2_nand2_1
X_9243_ _9243_/Q clkload4/A _9243_/D place2480/X VPWR VGND sg13g2_dfrbpq_1
X_9607__2783 _9607_/RESET_B VPWR VGND sg13g2_tiehi
X_6455_ _6455_/Y _6455_/A _6454_/X VPWR VGND sg13g2_nor2b_1
X_5406_ _5406_/Y _5402_/Y _5404_/Y _5405_/Y VPWR VGND sg13g2_a21oi_1
X_6386_ _6386_/Y _6385_/X _6430_/B2 _8873_/Q _6411_/A2 VPWR VGND sg13g2_a22oi_1
X_9174_ _9174_/Q clkload8/A _9174_/D place2465/X VPWR VGND sg13g2_dfrbpq_1
X_5337_ _5337_/Y _8389_/C _9502_/Q VPWR VGND sg13g2_nand2_1
X_8125_ _8125_/Y _8125_/A _8129_/B VPWR VGND sg13g2_nand2_1
XFILLER_114_394 VPWR VGND sg13g2_decap_4
X_5268_ _5268_/Y _5265_/Y _5268_/B _5268_/C VPWR VGND sg13g2_nand3b_1
X_8056_ _8056_/Y _8056_/A _9484_/Q _8056_/C _8056_/D VPWR VGND sg13g2_nand4_1
X_7007_ _7007_/Y _7946_/A _8825_/Q _8089_/A VPWR VGND sg13g2_nand3_1
XFILLER_68_492 VPWR VGND sg13g2_decap_8
XFILLER_68_470 VPWR VGND sg13g2_decap_4
X_5199_ _5205_/B _9866_/A _9867_/A VPWR VGND sg13g2_nand2_1
XFILLER_56_632 VPWR VGND sg13g2_fill_2
XFILLER_56_621 VPWR VGND sg13g2_decap_8
XFILLER_18_12 VPWR VGND sg13g2_fill_1
Xclkbuf_leaf_6_jtag_tck_i_regs _9678_/CLK clkbuf_leaf_6_jtag_tck_i_regs/A VPWR VGND
+ sg13g2_buf_16
X_8958_ _8958_/Q _9620_/CLK _8958_/D place2429/X VPWR VGND sg13g2_dfrbpq_1
XFILLER_18_78 VPWR VGND sg13g2_fill_2
XFILLER_71_668 VPWR VGND sg13g2_decap_8
XFILLER_71_646 VPWR VGND sg13g2_decap_8
X_7909_ _7909_/Y _8056_/A _9480_/Q _8056_/C _8056_/D VPWR VGND sg13g2_nand4_1
X_8889_ _8889_/Q _9253_/CLK _8889_/D place2487/X VPWR VGND sg13g2_dfrbpq_1
XFILLER_11_212 VPWR VGND sg13g2_decap_8
XFILLER_11_245 VPWR VGND sg13g2_fill_2
XFILLER_8_706 VPWR VGND sg13g2_fill_1
XFILLER_11_267 VPWR VGND sg13g2_decap_8
XFILLER_7_227 VPWR VGND sg13g2_fill_2
XFILLER_50_54 VPWR VGND sg13g2_decap_8
XFILLER_3_400 VPWR VGND sg13g2_fill_2
XFILLER_3_499 VPWR VGND sg13g2_decap_8
XFILLER_94_727 VPWR VGND sg13g2_decap_8
XFILLER_74_462 VPWR VGND sg13g2_decap_8
XFILLER_74_495 VPWR VGND sg13g2_fill_1
XFILLER_91_61 VPWR VGND sg13g2_decap_4
X_4570_ _4571_/A _9680_/Q _9681_/Q VPWR VGND sg13g2_nor2_1
Xplace2128 _5369_/C _5297_/Y VPWR VGND sg13g2_buf_1
Xplace2117 _8498_/B _7269_/A VPWR VGND sg13g2_buf_1
Xplace2106 _7725_/B _7816_/B VPWR VGND sg13g2_buf_1
XFILLER_116_615 VPWR VGND sg13g2_decap_8
Xplace2139 _5890_/D _5735_/D VPWR VGND sg13g2_buf_1
XFILLER_6_271 VPWR VGND sg13g2_fill_1
XFILLER_116_659 VPWR VGND sg13g2_fill_1
X_6240_ _6240_/Y _6271_/A _6238_/Y _6273_/A VPWR VGND sg13g2_a21oi_1
X_6171_ _6171_/Y _6365_/C _6365_/A _6171_/C _6365_/B VPWR VGND sg13g2_nand4_1
XFILLER_123_180 VPWR VGND sg13g2_decap_8
XFILLER_97_521 VPWR VGND sg13g2_fill_1
X_5122_ _5175_/C _5123_/A _5132_/B _9262_/Q VPWR VGND sg13g2_and3_1
XFILLER_97_554 VPWR VGND sg13g2_fill_1
XFILLER_85_716 VPWR VGND sg13g2_fill_1
XFILLER_69_245 VPWR VGND sg13g2_decap_8
XFILLER_27_0 VPWR VGND sg13g2_decap_4
X_5053_ _5053_/Y _5055_/A _5057_/A _5098_/A _5053_/D VPWR VGND sg13g2_nor4_1
XFILLER_84_204 VPWR VGND sg13g2_fill_2
XFILLER_38_621 VPWR VGND sg13g2_decap_8
X_9861_ _9861_/X _9861_/A VPWR VGND sg13g2_buf_1
X_8812_ _8812_/Q _9304_/CLK _8812_/D place2415/X VPWR VGND sg13g2_dfrbpq_1
XFILLER_92_281 VPWR VGND sg13g2_decap_4
XFILLER_52_123 VPWR VGND sg13g2_decap_4
X_5955_ _5955_/Y _5939_/Y _5954_/Y _5952_/Y _5953_/Y VPWR VGND sg13g2_a22oi_1
X_8743_ _8743_/Q _9675_/CLK _8743_/D place2449/X VPWR VGND sg13g2_dfrbpq_1
X_5886_ _5886_/Y _5880_/Y _5885_/X _5837_/Y VPWR VGND sg13g2_a21oi_1
XFILLER_80_498 VPWR VGND sg13g2_fill_2
XFILLER_80_487 VPWR VGND sg13g2_decap_8
X_8674_ _8674_/Q _8678_/CLK _8674_/D fanout946/X VPWR VGND sg13g2_dfrbpq_1
X_4906_ _4906_/Y _5000_/B1 _5012_/B _4905_/Y VPWR VGND sg13g2_o21ai_1
X_7625_ _7625_/Y _7625_/A _7625_/B _7625_/C VPWR VGND sg13g2_nor3_1
X_4837_ _4837_/Y _4880_/B _4831_/Y _4836_/Y VPWR VGND sg13g2_o21ai_1
XFILLER_119_442 VPWR VGND sg13g2_decap_8
X_7556_ _8911_/D _8911_/Q _7555_/Y _7812_/S VPWR VGND sg13g2_mux2_1
X_4768_ _4768_/Y _4959_/C _4983_/B _4768_/C _4855_/A VPWR VGND sg13g2_nand4_1
XFILLER_119_497 VPWR VGND sg13g2_fill_1
XFILLER_106_103 VPWR VGND sg13g2_fill_2
X_4699_ _4700_/B _9669_/Q _6955_/S VPWR VGND sg13g2_nor2_1
XFILLER_20_24 VPWR VGND sg13g2_fill_1
X_7487_ _7489_/C _7492_/A _9002_/Q _7490_/C VPWR VGND sg13g2_nor3_1
X_6507_ _6507_/Y _9206_/Q _6507_/A2 _6507_/B1 _9144_/Q VPWR VGND sg13g2_a22oi_1
XFILLER_105_7 VPWR VGND sg13g2_decap_8
X_9226_ _9226_/Q clkload7/A _9226_/D place2462/X VPWR VGND sg13g2_dfrbpq_1
X_6438_ _6438_/X _6438_/A _6438_/B _6438_/C _6438_/D VPWR VGND sg13g2_or4_1
XFILLER_106_169 VPWR VGND sg13g2_decap_4
Xplace1972 _7843_/A2 _5785_/C VPWR VGND sg13g2_buf_1
XFILLER_96_17 VPWR VGND sg13g2_fill_2
Xplace1950 _6441_/A2 _6496_/A2 VPWR VGND sg13g2_buf_1
Xplace1961 _6375_/A2 _6032_/Y VPWR VGND sg13g2_buf_1
XFILLER_0_403 VPWR VGND sg13g2_decap_8
X_9157_ _9157_/Q clkload8/A _9157_/D place2466/X VPWR VGND sg13g2_dfrbpq_1
Xplace1994 _8515_/D _5387_/B VPWR VGND sg13g2_buf_1
XFILLER_96_39 VPWR VGND sg13g2_fill_1
Xplace1983 _5600_/B _5615_/B VPWR VGND sg13g2_buf_1
X_6369_ _6369_/Y _6369_/A _6369_/B _6369_/C _6369_/D VPWR VGND sg13g2_nand4_1
X_8108_ _9054_/D _8130_/A1 _7892_/Y _8107_/Y VPWR VGND sg13g2_o21ai_1
XFILLER_88_576 VPWR VGND sg13g2_decap_4
X_9088_ _9088_/Q clkload5/A _9088_/D place2498/X VPWR VGND sg13g2_dfrbpq_1
X_8039_ _8039_/Y _8039_/A _8039_/B _8039_/C _8039_/D VPWR VGND sg13g2_nand4_1
XFILLER_91_719 VPWR VGND sg13g2_decap_8
XFILLER_28_175 VPWR VGND sg13g2_fill_2
XFILLER_44_624 VPWR VGND sg13g2_fill_1
XFILLER_83_281 VPWR VGND sg13g2_decap_8
XFILLER_71_421 VPWR VGND sg13g2_decap_8
XFILLER_16_337 VPWR VGND sg13g2_fill_1
XFILLER_43_134 VPWR VGND sg13g2_decap_8
XFILLER_71_487 VPWR VGND sg13g2_fill_2
XFILLER_43_178 VPWR VGND sg13g2_fill_2
XFILLER_12_554 VPWR VGND sg13g2_decap_4
XFILLER_12_532 VPWR VGND sg13g2_decap_8
Xinput2540 _7264_/B2 hartinfo_i[0] VPWR VGND sg13g2_buf_1
Xinput2551 _7287_/B2 hartinfo_i[1] VPWR VGND sg13g2_buf_1
XFILLER_12_598 VPWR VGND sg13g2_decap_8
XFILLER_12_587 VPWR VGND sg13g2_decap_4
Xinput2595 _5986_/A master_rdata_i[25] VPWR VGND sg13g2_buf_1
Xinput2584 _5952_/B master_rdata_i[15] VPWR VGND sg13g2_buf_1
XFILLER_61_97 VPWR VGND sg13g2_decap_8
Xinput2562 _7302_/B2 hartinfo_i[2] VPWR VGND sg13g2_buf_1
Xinput2573 _4744_/B1 jtag_tms_i VPWR VGND sg13g2_buf_1
XFILLER_8_558 VPWR VGND sg13g2_decap_8
XFILLER_79_510 VPWR VGND sg13g2_fill_2
XFILLER_3_230 VPWR VGND sg13g2_decap_8
XFILLER_105_191 VPWR VGND sg13g2_decap_8
XFILLER_79_576 VPWR VGND sg13g2_decap_8
XFILLER_79_565 VPWR VGND sg13g2_fill_1
XFILLER_121_684 VPWR VGND sg13g2_fill_1
XFILLER_67_749 VPWR VGND sg13g2_decap_8
XFILLER_81_229 VPWR VGND sg13g2_decap_8
XFILLER_35_602 VPWR VGND sg13g2_fill_2
XFILLER_90_741 VPWR VGND sg13g2_decap_8
XFILLER_34_156 VPWR VGND sg13g2_decap_8
XFILLER_35_668 VPWR VGND sg13g2_fill_2
X_5740_ _5740_/Y _5924_/D _5740_/A2 _5738_/Y _5739_/Y VPWR VGND sg13g2_a22oi_1
XFILLER_62_498 VPWR VGND sg13g2_fill_1
XFILLER_15_370 VPWR VGND sg13g2_decap_8
X_5671_ _5672_/A _5671_/A1 _5677_/A2 _5677_/B1 _8604_/Q VPWR VGND sg13g2_a22oi_1
X_7410_ _7412_/B _7410_/A _7834_/B _9091_/Q VPWR VGND sg13g2_nor3_1
X_4622_ _4673_/B _9455_/Q _9456_/Q VPWR VGND sg13g2_nand2_1
X_8390_ _9195_/D _5363_/C _8403_/A _8389_/Y VPWR VGND sg13g2_o21ai_1
X_4553_ _4554_/B _9217_/Q _7519_/C _7431_/D _9219_/Q VPWR VGND sg13g2_a22oi_1
X_7341_ _7341_/Y _8868_/Q _7533_/B1 _6994_/Y _7341_/B2 _7340_/Y VPWR VGND sg13g2_a221oi_1
X_4484_ _4666_/A _8706_/Q _9640_/Q VPWR VGND sg13g2_nor2b_1
X_7272_ _7275_/B _7296_/C _7297_/B _9084_/Q VPWR VGND sg13g2_nor3_1
X_9516__2864 _9516_/RESET_B VPWR VGND sg13g2_tiehi
X_6223_ _6459_/C _8446_/B _6451_/B _6262_/B _6333_/B VPWR VGND sg13g2_nor4_1
X_9011_ _9011_/Q clkload7/A _9011_/D place2476/X VPWR VGND sg13g2_dfrbpq_1
XFILLER_112_640 VPWR VGND sg13g2_decap_8
X_6154_ _6154_/Y _6333_/C _8446_/B _6333_/B _6246_/D VPWR VGND sg13g2_nor4_1
XFILLER_111_161 VPWR VGND sg13g2_decap_4
X_6085_ _6085_/X _8962_/Q _9024_/Q _9086_/Q _9148_/Q _6377_/S0 _6363_/S1 VPWR VGND
+ sg13g2_mux4_1
X_5105_ _7892_/D _8371_/C _9473_/Q VPWR VGND sg13g2_and2_1
XFILLER_111_183 VPWR VGND sg13g2_decap_8
X_5036_ _8530_/B _9408_/Q _9409_/Q _9410_/Q VPWR VGND sg13g2_a21o_1
XFILLER_38_451 VPWR VGND sg13g2_decap_8
XFILLER_65_281 VPWR VGND sg13g2_decap_8
XFILLER_81_763 VPWR VGND sg13g2_fill_2
XFILLER_80_251 VPWR VGND sg13g2_fill_2
X_6987_ _6987_/Y _6987_/A _6987_/B _6987_/C _6987_/D VPWR VGND sg13g2_nor4_1
X_5938_ _5998_/B _5938_/A _8528_/C _8534_/A VPWR VGND sg13g2_and3_1
X_8726_ _8726_/Q _9678_/CLK _8726_/D fanout966/X VPWR VGND sg13g2_dfrbpq_1
XFILLER_13_318 VPWR VGND sg13g2_fill_1
XFILLER_15_46 VPWR VGND sg13g2_fill_1
XFILLER_34_690 VPWR VGND sg13g2_fill_1
X_5869_ _5869_/X _5866_/Y _5867_/Y _5868_/Y VPWR VGND sg13g2_a21o_1
X_8657_ _8657_/Q _9701_/CLK _8657_/D fanout957/X VPWR VGND sg13g2_dfrbpq_1
X_8588_ _9286_/D _8588_/A VPWR VGND sg13g2_inv_1
X_7608_ _7608_/X _7718_/A _7608_/B _8977_/Q VPWR VGND sg13g2_or3_1
X_7539_ _7543_/B _7651_/A _7644_/B _8974_/Q VPWR VGND sg13g2_nor3_1
XFILLER_5_506 VPWR VGND sg13g2_decap_4
XFILLER_107_456 VPWR VGND sg13g2_fill_1
X_9209_ _9209_/Q _9662_/CLK _9209_/D place2447/X VPWR VGND sg13g2_dfrbpq_1
XFILLER_107_467 VPWR VGND sg13g2_fill_1
Xplace2481 place2481/X place2486/X VPWR VGND sg13g2_buf_1
Xplace2492 place2492/X place2507/X VPWR VGND sg13g2_buf_1
Xplace2470 place2470/X place2473/X VPWR VGND sg13g2_buf_1
Xplace1780 _8560_/A2 _8516_/X VPWR VGND sg13g2_buf_1
Xplace1791 _8579_/B1 _8587_/B1 VPWR VGND sg13g2_buf_1
XFILLER_49_716 VPWR VGND sg13g2_fill_1
Xhold3150 _8028_/A _9024_/Q VPWR VGND sg13g2_dlygate4sd3_1
XFILLER_0_255 VPWR VGND sg13g2_fill_1
XFILLER_0_233 VPWR VGND sg13g2_fill_1
XFILLER_1_778 VPWR VGND sg13g2_fill_1
XFILLER_76_513 VPWR VGND sg13g2_fill_1
Xhold3194 _8139_/A _9070_/Q VPWR VGND sg13g2_dlygate4sd3_1
Xhold3161 _8293_/A _9147_/Q VPWR VGND sg13g2_dlygate4sd3_1
Xhold3183 _8299_/A _9150_/Q VPWR VGND sg13g2_dlygate4sd3_1
Xhold3172 _6477_/B1 _9401_/Q VPWR VGND sg13g2_dlygate4sd3_1
XFILLER_76_568 VPWR VGND sg13g2_decap_8
XFILLER_64_708 VPWR VGND sg13g2_fill_2
XFILLER_29_473 VPWR VGND sg13g2_decap_8
XFILLER_72_730 VPWR VGND sg13g2_fill_1
XFILLER_16_156 VPWR VGND sg13g2_decap_8
XFILLER_17_668 VPWR VGND sg13g2_decap_4
XFILLER_17_679 VPWR VGND sg13g2_decap_4
X_9566__2824 _9566_/RESET_B VPWR VGND sg13g2_tiehi
XFILLER_72_796 VPWR VGND sg13g2_fill_1
XFILLER_72_785 VPWR VGND sg13g2_decap_4
XFILLER_16_189 VPWR VGND sg13g2_fill_2
XFILLER_32_616 VPWR VGND sg13g2_fill_2
XFILLER_44_487 VPWR VGND sg13g2_decap_4
Xi_dmi_jtag.i_dmi_jtag_tap.i_tck_inv.i_inv_2917 i_dmi_jtag.i_dmi_jtag_tap.i_tck_inv.i_inv_2917/Y
+ _9630_/CLK VPWR VGND sg13g2_inv_1
XFILLER_8_344 VPWR VGND sg13g2_decap_8
XFILLER_8_322 VPWR VGND sg13g2_fill_1
XFILLER_68_7 VPWR VGND sg13g2_decap_8
Xoutput2718 master_wdata_o[28] _5777_/X VPWR VGND sg13g2_buf_1
Xoutput2707 master_wdata_o[18] _5752_/Y VPWR VGND sg13g2_buf_1
Xoutput2729 master_wdata_o[9] _5722_/Y VPWR VGND sg13g2_buf_1
XFILLER_99_616 VPWR VGND sg13g2_fill_1
XFILLER_99_605 VPWR VGND sg13g2_decap_8
XFILLER_4_550 VPWR VGND sg13g2_decap_8
XFILLER_97_82 VPWR VGND sg13g2_fill_1
XFILLER_95_800 VPWR VGND sg13g2_fill_1
XFILLER_67_513 VPWR VGND sg13g2_decap_8
XFILLER_67_502 VPWR VGND sg13g2_decap_8
XFILLER_121_481 VPWR VGND sg13g2_fill_1
XFILLER_67_568 VPWR VGND sg13g2_decap_8
XFILLER_67_557 VPWR VGND sg13g2_decap_4
XFILLER_82_527 VPWR VGND sg13g2_fill_2
XFILLER_82_516 VPWR VGND sg13g2_fill_1
X_6910_ _9621_/D _6909_/X _9621_/Q _6910_/S VPWR VGND sg13g2_mux2_1
XFILLER_94_398 VPWR VGND sg13g2_fill_2
XFILLER_63_741 VPWR VGND sg13g2_fill_2
X_7890_ _8960_/D _5345_/C _7899_/A _7888_/Y VPWR VGND sg13g2_o21ai_1
XFILLER_35_410 VPWR VGND sg13g2_decap_8
X_6841_ _8500_/B _9256_/Q _9257_/Q VPWR VGND sg13g2_nor2_1
X_9560_ _9560_/Q _9587_/CLK _9560_/D _9560_/RESET_B VPWR VGND sg13g2_dfrbpq_1
XFILLER_62_284 VPWR VGND sg13g2_decap_8
XFILLER_50_424 VPWR VGND sg13g2_fill_1
X_6772_ _9531_/D _9531_/Q _9441_/Q _6779_/S VPWR VGND sg13g2_mux2_1
XFILLER_94_0 VPWR VGND sg13g2_decap_8
X_8511_ _8511_/Y _8744_/Q _8511_/B _8511_/C VPWR VGND sg13g2_nand3b_1
XFILLER_22_126 VPWR VGND sg13g2_fill_1
X_9491_ _9491_/Q _9621_/CLK _9491_/D _9491_/RESET_B VPWR VGND sg13g2_dfrbpq_1
X_5723_ _5723_/Y _5735_/A _5735_/B _9308_/Q _5735_/D VPWR VGND sg13g2_nand4_1
XFILLER_31_671 VPWR VGND sg13g2_decap_4
X_5654_ _5654_/Y _5658_/A _5654_/B VPWR VGND sg13g2_nand2_1
X_8442_ _8442_/Y _8444_/A _9226_/Q _8448_/C VPWR VGND sg13g2_nand3_1
X_4605_ _4606_/B _9665_/Q _4602_/B _4604_/Y VPWR VGND sg13g2_o21ai_1
X_8373_ _8373_/Y _8409_/A _9187_/Q _8375_/C VPWR VGND sg13g2_nand3_1
XFILLER_30_192 VPWR VGND sg13g2_decap_8
X_5585_ _5585_/Y _5585_/A _5585_/B _8651_/Q _5585_/D VPWR VGND sg13g2_nand4_1
X_7324_ _7324_/Y _7323_/Y _7319_/Y _7459_/A VPWR VGND sg13g2_a21oi_1
XFILLER_116_264 VPWR VGND sg13g2_decap_8
X_4536_ _7028_/A _7245_/A _7032_/C _7245_/D VPWR VGND sg13g2_nand3_1
XFILLER_117_59 VPWR VGND sg13g2_fill_2
XFILLER_116_297 VPWR VGND sg13g2_decap_8
X_7255_ _7258_/B _9176_/Q _7815_/B VPWR VGND sg13g2_nor2_1
X_4467_ _4468_/B _4467_/A _4358_/B VPWR VGND sg13g2_nor2b_1
X_4398_ _4399_/A _5435_/A2 _8672_/Q _4398_/B1 _5469_/B2 VPWR VGND sg13g2_a22oi_1
X_6206_ _6206_/Y _6077_/Y _6105_/Y _6177_/Y VPWR VGND sg13g2_o21ai_1
X_7186_ _7213_/S _7187_/D _6962_/Y _6974_/Y VPWR VGND sg13g2_o21ai_1
X_6137_ _6137_/X _8966_/Q _9028_/Q _9090_/Q _9152_/Q _6377_/S0 _6381_/S1 VPWR VGND
+ sg13g2_mux4_1
XFILLER_100_632 VPWR VGND sg13g2_decap_4
XFILLER_58_546 VPWR VGND sg13g2_fill_2
XFILLER_100_676 VPWR VGND sg13g2_decap_4
XFILLER_100_665 VPWR VGND sg13g2_fill_2
X_6068_ _9344_/D _6131_/D _6067_/X _6057_/Y VPWR VGND sg13g2_a21oi_1
XFILLER_100_698 VPWR VGND sg13g2_fill_2
XFILLER_73_549 VPWR VGND sg13g2_fill_2
X_5019_ _5020_/A _9407_/Q _4972_/B _5018_/Y VPWR VGND sg13g2_a21oi_1
XFILLER_53_240 VPWR VGND sg13g2_fill_2
XFILLER_14_605 VPWR VGND sg13g2_fill_1
XFILLER_26_56 VPWR VGND sg13g2_fill_1
XFILLER_53_284 VPWR VGND sg13g2_fill_1
XFILLER_41_413 VPWR VGND sg13g2_decap_8
XFILLER_13_137 VPWR VGND sg13g2_fill_1
XFILLER_14_649 VPWR VGND sg13g2_decap_4
X_8709_ _8709_/Q _9649_/CLK _8709_/D fanout974/X VPWR VGND sg13g2_dfrbpq_1
XFILLER_9_119 VPWR VGND sg13g2_fill_2
X_9689_ _9689_/Q _9689_/CLK _9689_/D fanout962/X VPWR VGND sg13g2_dfrbpq_1
XFILLER_42_77 VPWR VGND sg13g2_decap_8
XFILLER_108_765 VPWR VGND sg13g2_decap_8
XFILLER_123_768 VPWR VGND sg13g2_decap_8
XFILLER_107_92 VPWR VGND sg13g2_decap_4
XFILLER_89_682 VPWR VGND sg13g2_fill_1
XFILLER_89_671 VPWR VGND sg13g2_decap_8
XFILLER_3_49 VPWR VGND sg13g2_decap_8
XFILLER_76_321 VPWR VGND sg13g2_fill_2
XFILLER_67_52 VPWR VGND sg13g2_decap_4
XFILLER_92_803 VPWR VGND sg13g2_fill_2
XFILLER_76_354 VPWR VGND sg13g2_fill_1
XFILLER_57_590 VPWR VGND sg13g2_decap_8
XFILLER_17_410 VPWR VGND sg13g2_decap_8
XFILLER_123_91 VPWR VGND sg13g2_decap_8
XFILLER_83_40 VPWR VGND sg13g2_fill_2
XFILLER_45_796 VPWR VGND sg13g2_fill_1
XFILLER_60_744 VPWR VGND sg13g2_decap_8
XFILLER_20_608 VPWR VGND sg13g2_decap_8
XFILLER_66_4 VPWR VGND sg13g2_fill_2
XFILLER_9_697 VPWR VGND sg13g2_fill_1
XFILLER_8_196 VPWR VGND sg13g2_fill_1
X_5370_ _8810_/D _5375_/A _5375_/B _5370_/C _5375_/D VPWR VGND sg13g2_nor4_1
X_4321_ _5234_/A _9872_/A VPWR VGND sg13g2_inv_1
XFILLER_99_479 VPWR VGND sg13g2_fill_1
XFILLER_99_457 VPWR VGND sg13g2_decap_8
XFILLER_87_608 VPWR VGND sg13g2_decap_8
X_7040_ _7040_/Y _7889_/D _6966_/Y _7036_/X _4436_/A VPWR VGND sg13g2_a22oi_1
XFILLER_122_790 VPWR VGND sg13g2_decap_4
XFILLER_95_652 VPWR VGND sg13g2_decap_8
XFILLER_67_332 VPWR VGND sg13g2_decap_8
X_8991_ _8991_/Q _9242_/CLK _8991_/D place2494/X VPWR VGND sg13g2_dfrbpq_1
XFILLER_28_719 VPWR VGND sg13g2_fill_2
XFILLER_103_17 VPWR VGND sg13g2_fill_1
XFILLER_82_313 VPWR VGND sg13g2_fill_2
X_7942_ _7942_/Y _7948_/A _8983_/Q _8401_/C VPWR VGND sg13g2_nand3_1
XFILLER_82_346 VPWR VGND sg13g2_fill_2
X_9612_ _9612_/Q _9615_/CLK _9612_/D _9612_/RESET_B VPWR VGND sg13g2_dfrbpq_1
X_7873_ _8946_/D _8946_/Q _7616_/Y _7881_/S VPWR VGND sg13g2_mux2_1
XFILLER_51_700 VPWR VGND sg13g2_decap_8
XFILLER_23_402 VPWR VGND sg13g2_decap_4
XFILLER_36_785 VPWR VGND sg13g2_fill_2
X_6824_ _9572_/D _9605_/Q _9572_/Q _6836_/S VPWR VGND sg13g2_mux2_1
X_9543_ _9543_/Q _9645_/CLK _9543_/D _9543_/RESET_B VPWR VGND sg13g2_dfrbpq_1
X_6755_ _9514_/D _9514_/Q _9424_/Q _6783_/S VPWR VGND sg13g2_mux2_1
XFILLER_50_276 VPWR VGND sg13g2_fill_1
XFILLER_50_265 VPWR VGND sg13g2_decap_8
X_5706_ _8716_/D _9651_/D _5706_/B VPWR VGND sg13g2_and2_1
X_9474_ _9474_/Q _9501_/CLK _9474_/D _9474_/RESET_B VPWR VGND sg13g2_dfrbpq_1
X_6686_ _6686_/Y _9460_/Q _6686_/B VPWR VGND sg13g2_nor2_1
X_8425_ _9216_/D _5363_/C _8432_/A _8424_/Y VPWR VGND sg13g2_o21ai_1
XFILLER_12_47 VPWR VGND sg13g2_decap_8
X_5637_ _8621_/D _5637_/A VPWR VGND sg13g2_inv_1
X_5568_ _5568_/Y _8645_/Q _5592_/A2 _5580_/B1 _8644_/Q VPWR VGND sg13g2_a22oi_1
X_8356_ _9178_/D _5346_/C _8375_/A _8355_/Y VPWR VGND sg13g2_o21ai_1
XFILLER_117_595 VPWR VGND sg13g2_fill_2
X_7307_ _8898_/D _8898_/Q _7306_/Y _7848_/S VPWR VGND sg13g2_mux2_1
X_4519_ _8819_/D _4516_/Y _4518_/Y _7132_/B VPWR VGND sg13g2_a21oi_1
X_8287_ _8287_/Y _9144_/Q _8287_/B VPWR VGND sg13g2_nand2_1
XFILLER_104_223 VPWR VGND sg13g2_fill_2
X_5499_ _5499_/Y _5625_/B _6541_/A _6541_/B VPWR VGND sg13g2_nand3_1
X_7238_ _7238_/Y _7238_/A1 _7236_/Y _7237_/Y VPWR VGND sg13g2_a21oi_1
XFILLER_98_490 VPWR VGND sg13g2_decap_8
X_7169_ _7169_/Y _7818_/B _9482_/Q _7237_/B1 _7176_/B2 VPWR VGND sg13g2_a22oi_1
XFILLER_73_302 VPWR VGND sg13g2_fill_1
XFILLER_58_387 VPWR VGND sg13g2_decap_4
XFILLER_39_590 VPWR VGND sg13g2_decap_8
XFILLER_27_774 VPWR VGND sg13g2_decap_4
XFILLER_42_722 VPWR VGND sg13g2_fill_1
XFILLER_53_43 VPWR VGND sg13g2_fill_1
XFILLER_14_435 VPWR VGND sg13g2_fill_2
X_9475__2905 _9475_/RESET_B VPWR VGND sg13g2_tiehi
XFILLER_14_479 VPWR VGND sg13g2_fill_1
XFILLER_41_265 VPWR VGND sg13g2_fill_2
XFILLER_42_777 VPWR VGND sg13g2_decap_8
XFILLER_22_490 VPWR VGND sg13g2_decap_8
XFILLER_10_674 VPWR VGND sg13g2_fill_2
XFILLER_6_667 VPWR VGND sg13g2_decap_4
XFILLER_123_532 VPWR VGND sg13g2_decap_8
XFILLER_45_9 VPWR VGND sg13g2_fill_1
XFILLER_49_398 VPWR VGND sg13g2_decap_8
XFILLER_80_806 VPWR VGND sg13g2_fill_2
XFILLER_52_519 VPWR VGND sg13g2_decap_4
XFILLER_17_240 VPWR VGND sg13g2_decap_4
X_4870_ _4870_/Y _9387_/Q _4972_/B _4959_/A _4869_/Y VPWR VGND sg13g2_a22oi_1
XFILLER_20_405 VPWR VGND sg13g2_decap_4
XFILLER_33_777 VPWR VGND sg13g2_decap_8
XFILLER_33_788 VPWR VGND sg13g2_fill_1
X_6540_ _6545_/D _9454_/Q _9694_/Q VPWR VGND sg13g2_nor2b_1
XFILLER_13_490 VPWR VGND sg13g2_decap_8
X_6471_ _9400_/D _6469_/Y _6491_/A2 _6470_/Y VPWR VGND sg13g2_a21oi_1
XFILLER_118_359 VPWR VGND sg13g2_decap_4
X_8210_ _9105_/D _8222_/A1 _8080_/Y _8209_/Y VPWR VGND sg13g2_o21ai_1
X_5422_ _5422_/Y _5628_/B _9695_/Q _5418_/Y VPWR VGND sg13g2_o21ai_1
X_9190_ _9190_/Q clkload8/A _9190_/D place2476/X VPWR VGND sg13g2_dfrbpq_1
XFILLER_114_521 VPWR VGND sg13g2_fill_2
X_8141_ _8141_/Y _8141_/A _8159_/B VPWR VGND sg13g2_nand2_1
X_5353_ _8793_/D _5366_/A _5366_/B _5353_/C _5366_/D VPWR VGND sg13g2_nor4_1
X_4304_ _7245_/D _9470_/Q VPWR VGND sg13g2_inv_1
X_8072_ _9040_/D _5372_/D _8071_/Y _8070_/Y VPWR VGND sg13g2_o21ai_1
X_5284_ _5287_/A _5280_/Y _5254_/C _4326_/Y VPWR VGND sg13g2_o21ai_1
X_7023_ _8829_/D _8222_/A1 _7008_/Y _7022_/Y VPWR VGND sg13g2_o21ai_1
XFILLER_68_663 VPWR VGND sg13g2_decap_8
XFILLER_95_482 VPWR VGND sg13g2_fill_1
XFILLER_28_538 VPWR VGND sg13g2_decap_4
XFILLER_55_335 VPWR VGND sg13g2_decap_8
X_8974_ _8974_/Q clkload7/A _8974_/D place2459/X VPWR VGND sg13g2_dfrbpq_1
XFILLER_82_165 VPWR VGND sg13g2_decap_8
X_7925_ _7925_/Y _8086_/A _9487_/Q _8056_/C _8086_/D VPWR VGND sg13g2_nand4_1
X_7856_ _8933_/D _8933_/Q _7360_/Y _7885_/S VPWR VGND sg13g2_mux2_1
XFILLER_24_744 VPWR VGND sg13g2_decap_8
XFILLER_36_582 VPWR VGND sg13g2_decap_4
XFILLER_36_593 VPWR VGND sg13g2_fill_1
X_9594__2796 _9594_/RESET_B VPWR VGND sg13g2_tiehi
X_6807_ _6813_/S _8725_/Q _5492_/A _6806_/Y VPWR VGND sg13g2_o21ai_1
X_9526_ _9526_/Q _9567_/CLK _9526_/D _9526_/RESET_B VPWR VGND sg13g2_dfrbpq_1
X_7787_ _7791_/C _8811_/Q _7787_/B VPWR VGND sg13g2_nand2_1
XFILLER_23_24 VPWR VGND sg13g2_fill_1
XFILLER_23_287 VPWR VGND sg13g2_fill_1
X_4999_ _4999_/Y _4999_/A _4999_/B VPWR VGND sg13g2_nand2_1
X_6738_ _6745_/C _8700_/Q _9546_/Q VPWR VGND sg13g2_xor2_1
XFILLER_7_409 VPWR VGND sg13g2_decap_8
XFILLER_109_326 VPWR VGND sg13g2_decap_8
X_9457_ _9457_/Q _9649_/CLK _9457_/D fanout975/X VPWR VGND sg13g2_dfrbpq_1
X_6669_ _6669_/Y _6672_/C _8654_/Q _9586_/Q _6669_/B2 VPWR VGND sg13g2_a22oi_1
X_8408_ _9204_/D _5372_/C _8407_/A _8407_/Y VPWR VGND sg13g2_o21ai_1
X_9388_ _9388_/Q clkload9/A _9388_/D place2505/X VPWR VGND sg13g2_dfrbpq_1
X_8339_ _8339_/Y _8339_/A _8343_/B VPWR VGND sg13g2_nand2_1
XFILLER_2_136 VPWR VGND sg13g2_fill_1
XFILLER_2_158 VPWR VGND sg13g2_fill_1
XFILLER_48_21 VPWR VGND sg13g2_fill_1
XFILLER_120_557 VPWR VGND sg13g2_fill_1
XFILLER_19_505 VPWR VGND sg13g2_decap_8
X_9529__2851 _9529_/RESET_B VPWR VGND sg13g2_tiehi
XFILLER_46_324 VPWR VGND sg13g2_decap_8
XFILLER_74_655 VPWR VGND sg13g2_decap_4
XFILLER_0_28 VPWR VGND sg13g2_decap_8
XFILLER_46_335 VPWR VGND sg13g2_decap_8
XFILLER_64_31 VPWR VGND sg13g2_fill_1
XFILLER_64_86 VPWR VGND sg13g2_decap_8
XFILLER_61_349 VPWR VGND sg13g2_decap_8
XFILLER_61_338 VPWR VGND sg13g2_decap_4
XFILLER_15_733 VPWR VGND sg13g2_fill_1
XFILLER_27_582 VPWR VGND sg13g2_fill_2
XFILLER_14_254 VPWR VGND sg13g2_decap_8
XFILLER_80_63 VPWR VGND sg13g2_decap_8
XFILLER_30_769 VPWR VGND sg13g2_fill_2
XFILLER_6_420 VPWR VGND sg13g2_fill_2
XFILLER_89_83 VPWR VGND sg13g2_fill_2
XFILLER_69_427 VPWR VGND sg13g2_decap_8
XFILLER_2_670 VPWR VGND sg13g2_decap_8
XFILLER_38_803 VPWR VGND sg13g2_fill_2
XFILLER_65_633 VPWR VGND sg13g2_decap_8
XFILLER_65_644 VPWR VGND sg13g2_fill_1
X_5971_ _5971_/Y _9491_/Q _5781_/Y _5865_/X _5980_/B2 VPWR VGND sg13g2_a22oi_1
XFILLER_92_485 VPWR VGND sg13g2_decap_8
XFILLER_80_625 VPWR VGND sg13g2_decap_8
XFILLER_64_154 VPWR VGND sg13g2_decap_4
XFILLER_52_305 VPWR VGND sg13g2_decap_8
XFILLER_25_508 VPWR VGND sg13g2_fill_2
X_7710_ _7714_/A _7704_/Y _7709_/Y _4560_/B VPWR VGND sg13g2_o21ai_1
X_8690_ _8690_/Q _9630_/CLK _8690_/D fanout955/X VPWR VGND sg13g2_dfrbpq_1
XFILLER_18_593 VPWR VGND sg13g2_decap_8
X_4922_ _4922_/Y _5008_/A _9362_/Q VPWR VGND sg13g2_nand2b_1
XFILLER_100_18 VPWR VGND sg13g2_fill_1
X_7641_ _7641_/Y _7641_/A _7641_/B VPWR VGND sg13g2_nand2_1
XFILLER_20_213 VPWR VGND sg13g2_decap_8
XFILLER_21_747 VPWR VGND sg13g2_decap_8
X_4853_ _4854_/C _4853_/A _9353_/Q VPWR VGND sg13g2_nor2_1
X_7572_ _7574_/C _9213_/Q _7695_/A2 _7551_/B _9262_/Q VPWR VGND sg13g2_a22oi_1
X_4784_ _4784_/Y _4855_/A _9347_/Q VPWR VGND sg13g2_nand2b_1
X_9311_ _9311_/Q _9410_/CLK _9311_/D place2406/X VPWR VGND sg13g2_dfrbpq_1
X_6523_ _6524_/A _6523_/A _7519_/D _6523_/C _6523_/D VPWR VGND sg13g2_nand4_1
X_9579__2811 _9579_/RESET_B VPWR VGND sg13g2_tiehi
XFILLER_107_808 VPWR VGND sg13g2_fill_1
X_6454_ _6454_/X _9012_/Q _9074_/Q _9136_/Q _9198_/Q _6514_/S0 _6514_/S1 VPWR VGND
+ sg13g2_mux4_1
X_9242_ _9242_/Q _9242_/CLK _9242_/D place2494/X VPWR VGND sg13g2_dfrbpq_1
X_5405_ _5405_/Y _7028_/B _4526_/Y _8746_/Q VPWR VGND sg13g2_a21oi_1
X_9173_ _9173_/Q _9199_/CLK _9173_/D place2433/X VPWR VGND sg13g2_dfrbpq_1
X_6385_ _6385_/X _8999_/Q _9061_/Q _9123_/Q _9185_/Q _6400_/S0 _6400_/S1 VPWR VGND
+ sg13g2_mux4_1
XFILLER_88_703 VPWR VGND sg13g2_fill_1
X_5336_ _8782_/D _5341_/A1 _5374_/C _5335_/Y _5336_/B2 VPWR VGND sg13g2_a22oi_1
X_8124_ _9062_/D _8130_/A1 _8047_/Y _8123_/Y VPWR VGND sg13g2_o21ai_1
XFILLER_102_535 VPWR VGND sg13g2_fill_1
X_5267_ _5267_/Y _9878_/A _5280_/A _5280_/B _5291_/C VPWR VGND sg13g2_nand4_1
X_8055_ _8055_/Y _8055_/A _8055_/B VPWR VGND sg13g2_nand2_1
X_7006_ _7951_/C _7028_/A _7028_/B _7006_/C VPWR VGND sg13g2_nor3_1
X_5198_ _5198_/Y _5215_/A _9866_/A _9867_/A VPWR VGND sg13g2_a21oi_1
XFILLER_18_46 VPWR VGND sg13g2_fill_1
XFILLER_28_335 VPWR VGND sg13g2_decap_8
XFILLER_28_346 VPWR VGND sg13g2_fill_2
X_8957_ _8957_/Q _9504_/CLK _8957_/D place2428/X VPWR VGND sg13g2_dfrbpq_1
XFILLER_71_625 VPWR VGND sg13g2_decap_8
XFILLER_16_508 VPWR VGND sg13g2_fill_2
XFILLER_28_368 VPWR VGND sg13g2_decap_8
X_7908_ _7908_/Y _7917_/A _8968_/Q _8375_/C VPWR VGND sg13g2_nand3_1
X_8888_ _8888_/Q _9253_/CLK _8888_/D place2456/X VPWR VGND sg13g2_dfrbpq_1
XFILLER_34_67 VPWR VGND sg13g2_decap_4
X_7839_ _7839_/Y _9082_/Q _7839_/B _7839_/C VPWR VGND sg13g2_nand3b_1
X_9509_ _9509_/Q _9511_/CLK _9509_/D _9509_/RESET_B VPWR VGND sg13g2_dfrbpq_1
XFILLER_50_33 VPWR VGND sg13g2_decap_8
Xclkload0 clkload0/X clkload0/A VPWR VGND sg13g2_buf_16
XFILLER_20_791 VPWR VGND sg13g2_decap_8
XFILLER_109_178 VPWR VGND sg13g2_fill_2
XFILLER_109_167 VPWR VGND sg13g2_decap_8
XFILLER_3_434 VPWR VGND sg13g2_decap_8
XFILLER_79_725 VPWR VGND sg13g2_fill_2
XFILLER_3_478 VPWR VGND sg13g2_decap_8
XFILLER_105_395 VPWR VGND sg13g2_fill_1
XFILLER_94_706 VPWR VGND sg13g2_decap_8
XFILLER_79_769 VPWR VGND sg13g2_fill_2
XFILLER_78_268 VPWR VGND sg13g2_decap_8
XFILLER_120_398 VPWR VGND sg13g2_decap_8
XFILLER_47_622 VPWR VGND sg13g2_fill_2
XFILLER_101_590 VPWR VGND sg13g2_fill_1
XFILLER_19_324 VPWR VGND sg13g2_decap_8
XFILLER_62_614 VPWR VGND sg13g2_fill_2
XFILLER_47_699 VPWR VGND sg13g2_fill_1
XFILLER_19_379 VPWR VGND sg13g2_fill_1
XFILLER_46_154 VPWR VGND sg13g2_fill_2
XFILLER_62_647 VPWR VGND sg13g2_fill_2
XFILLER_62_636 VPWR VGND sg13g2_fill_1
XFILLER_34_349 VPWR VGND sg13g2_decap_8
XFILLER_91_84 VPWR VGND sg13g2_fill_1
XFILLER_30_522 VPWR VGND sg13g2_fill_1
Xplace2107 _7816_/B _7838_/B VPWR VGND sg13g2_buf_1
Xplace2118 _6737_/A _4462_/A VPWR VGND sg13g2_buf_1
Xplace2129 _5366_/C _5275_/Y VPWR VGND sg13g2_buf_1
XFILLER_97_500 VPWR VGND sg13g2_decap_8
X_6170_ _6170_/Y _6510_/B _6399_/A _6399_/B VPWR VGND sg13g2_a21oi_1
X_5121_ _8755_/D _5080_/Y _5347_/C _5120_/Y _5288_/B2 VPWR VGND sg13g2_a22oi_1
XFILLER_57_408 VPWR VGND sg13g2_decap_4
XFILLER_111_398 VPWR VGND sg13g2_decap_8
X_5052_ _5053_/D _5085_/C _9859_/A _5049_/Y _5096_/C _5041_/Y VPWR VGND sg13g2_a221oi_1
XFILLER_84_227 VPWR VGND sg13g2_fill_2
XFILLER_84_216 VPWR VGND sg13g2_decap_8
XFILLER_84_249 VPWR VGND sg13g2_decap_8
X_9860_ _9860_/X _9860_/A VPWR VGND sg13g2_buf_1
X_9470__2910 _9470_/RESET_B VPWR VGND sg13g2_tiehi
XFILLER_93_783 VPWR VGND sg13g2_fill_2
X_8811_ _8811_/Q _9304_/CLK _8811_/D place2421/X VPWR VGND sg13g2_dfrbpq_1
XFILLER_80_433 VPWR VGND sg13g2_decap_4
X_8742_ _8742_/Q _9686_/CLK _8742_/D fanout964/X VPWR VGND sg13g2_dfrbpq_1
XFILLER_52_102 VPWR VGND sg13g2_decap_8
X_5954_ _5954_/Y _5954_/A _6004_/A _5954_/C _8534_/A VPWR VGND sg13g2_nand4_1
XFILLER_80_466 VPWR VGND sg13g2_decap_8
XFILLER_52_146 VPWR VGND sg13g2_decap_8
XFILLER_40_308 VPWR VGND sg13g2_fill_1
X_5885_ _5885_/X _5882_/Y _5883_/Y _5884_/Y VPWR VGND sg13g2_a21o_1
X_4905_ _4905_/Y _9391_/Q _4934_/B _4904_/Y VPWR VGND sg13g2_a21oi_1
X_8673_ _8673_/Q _8678_/CLK _8673_/D fanout944/X VPWR VGND sg13g2_dfrbpq_1
XFILLER_21_511 VPWR VGND sg13g2_decap_8
X_7624_ _7625_/B _9195_/Q _7627_/B _7801_/A VPWR VGND sg13g2_o21ai_1
X_4836_ _4836_/Y _9382_/Q _4891_/A2 _4835_/Y VPWR VGND sg13g2_a21oi_1
X_7555_ _7555_/Y _7829_/A _7555_/B VPWR VGND sg13g2_nor2_1
XFILLER_119_432 VPWR VGND sg13g2_decap_4
XFILLER_107_605 VPWR VGND sg13g2_decap_8
X_4767_ _4768_/C _6010_/A0 _4827_/A VPWR VGND sg13g2_nand2b_1
X_6506_ _6506_/Y _9020_/Q _6506_/A2 _6506_/B1 _9082_/Q VPWR VGND sg13g2_a22oi_1
X_4698_ _9675_/D _6955_/S _4702_/A _4697_/Y VPWR VGND sg13g2_o21ai_1
X_7486_ _7486_/X _7486_/A _7492_/B _8971_/Q VPWR VGND sg13g2_or3_1
X_6437_ _6437_/Y _6312_/C _6463_/A2 _6437_/B1 VPWR VGND sg13g2_a21oi_1
X_9225_ _9225_/Q clkload7/A _9225_/D place2462/X VPWR VGND sg13g2_dfrbpq_1
Xplace1973 _7828_/A2 _5785_/C VPWR VGND sg13g2_buf_1
Xplace1940 _7533_/B1 _7680_/B1 VPWR VGND sg13g2_buf_1
X_6368_ _6369_/C _6438_/A _6438_/B _6189_/C VPWR VGND sg13g2_o21ai_1
X_9156_ _9156_/Q _9188_/CLK _9156_/D place2475/X VPWR VGND sg13g2_dfrbpq_1
Xplace1962 _7176_/B2 _6962_/D VPWR VGND sg13g2_buf_1
Xplace1951 _6496_/A2 _6511_/A2 VPWR VGND sg13g2_buf_1
X_5319_ _5372_/C _5319_/A _9499_/Q VPWR VGND sg13g2_nand2_1
Xplace1995 _5387_/B _5380_/Y VPWR VGND sg13g2_buf_1
Xplace1984 _5615_/B _5621_/B VPWR VGND sg13g2_buf_1
X_8107_ _8107_/Y _8107_/A _8129_/B VPWR VGND sg13g2_nand2_1
XFILLER_102_332 VPWR VGND sg13g2_decap_4
XFILLER_76_717 VPWR VGND sg13g2_fill_2
XFILLER_76_706 VPWR VGND sg13g2_fill_2
X_9087_ _9087_/Q _9153_/CLK _9087_/D place2497/X VPWR VGND sg13g2_dfrbpq_1
X_6299_ _6299_/Y _6408_/B _6103_/B _6332_/C _6259_/Y VPWR VGND sg13g2_a22oi_1
XFILLER_88_588 VPWR VGND sg13g2_decap_4
X_8038_ _8038_/Y _8038_/A _8099_/B VPWR VGND sg13g2_nand2_1
XFILLER_91_709 VPWR VGND sg13g2_decap_4
XFILLER_75_238 VPWR VGND sg13g2_fill_1
XFILLER_56_452 VPWR VGND sg13g2_decap_8
XFILLER_44_603 VPWR VGND sg13g2_fill_2
XFILLER_16_316 VPWR VGND sg13g2_decap_8
XFILLER_29_699 VPWR VGND sg13g2_fill_1
XFILLER_12_522 VPWR VGND sg13g2_fill_1
Xinput2552 _7654_/B2 hartinfo_i[20] VPWR VGND sg13g2_buf_1
Xinput2541 _7441_/B2 hartinfo_i[10] VPWR VGND sg13g2_buf_1
Xinput2585 _5899_/A1 master_rdata_i[16] VPWR VGND sg13g2_buf_1
Xinput2563 _7846_/B2 hartinfo_i[30] VPWR VGND sg13g2_buf_1
Xinput2574 input2574/X jtag_trst_ni VPWR VGND sg13g2_buf_1
Xinput2596 _5989_/A master_rdata_i[26] VPWR VGND sg13g2_buf_1
XFILLER_6_49 VPWR VGND sg13g2_fill_2
XFILLER_4_743 VPWR VGND sg13g2_fill_1
XFILLER_4_754 VPWR VGND sg13g2_decap_4
XFILLER_106_693 VPWR VGND sg13g2_decap_4
XFILLER_106_682 VPWR VGND sg13g2_decap_4
XFILLER_4_787 VPWR VGND sg13g2_decap_4
XFILLER_3_286 VPWR VGND sg13g2_decap_8
XFILLER_105_181 VPWR VGND sg13g2_decap_4
XFILLER_79_555 VPWR VGND sg13g2_fill_2
XFILLER_79_544 VPWR VGND sg13g2_decap_8
XFILLER_120_173 VPWR VGND sg13g2_decap_4
XFILLER_67_728 VPWR VGND sg13g2_decap_8
XFILLER_86_84 VPWR VGND sg13g2_fill_1
XFILLER_81_208 VPWR VGND sg13g2_decap_8
XFILLER_75_761 VPWR VGND sg13g2_decap_8
XFILLER_74_260 VPWR VGND sg13g2_fill_2
XFILLER_19_165 VPWR VGND sg13g2_decap_8
XFILLER_90_720 VPWR VGND sg13g2_decap_8
XFILLER_47_485 VPWR VGND sg13g2_fill_1
XFILLER_34_102 VPWR VGND sg13g2_decap_8
XFILLER_35_647 VPWR VGND sg13g2_decap_8
XFILLER_34_135 VPWR VGND sg13g2_decap_8
XFILLER_50_617 VPWR VGND sg13g2_decap_4
X_5670_ _8605_/D _5670_/A VPWR VGND sg13g2_inv_1
X_4621_ _8742_/D _6804_/B _4621_/B _4621_/C VPWR VGND sg13g2_nand3b_1
Xi_dmi_jtag.i_dmi_jtag_tap.i_dft_tck_mux.i_mux i_dmi_jtag.i_dmi_jtag_tap.i_dft_tck_mux.i_mux/X
+ i_dmi_jtag.i_dmi_jtag_tap.i_tck_inv.i_inv_2917/Y clkbuf_1_0__f_jtag_tck_i/X testmode_i
+ VPWR VGND sg13g2_mux2_1
X_4552_ _4554_/C _5383_/B _5826_/A _9220_/Q VPWR VGND sg13g2_nand3_1
X_7340_ _7340_/Y _7340_/A _7340_/B _7340_/C VPWR VGND sg13g2_nand3_1
XFILLER_116_424 VPWR VGND sg13g2_decap_8
X_4483_ _4483_/Y _4483_/A1 _4334_/Y _4347_/B VPWR VGND sg13g2_o21ai_1
XFILLER_7_592 VPWR VGND sg13g2_fill_1
X_7271_ _7275_/A _7278_/C _9115_/Q _7295_/C VPWR VGND sg13g2_nor3_1
XFILLER_116_468 VPWR VGND sg13g2_decap_8
X_6222_ _9363_/D _6505_/A2 _6220_/Y _6221_/Y VPWR VGND sg13g2_a21oi_1
X_9010_ _9010_/Q clkload7/A _9010_/D place2458/X VPWR VGND sg13g2_dfrbpq_1
XFILLER_106_39 VPWR VGND sg13g2_decap_4
XFILLER_97_352 VPWR VGND sg13g2_fill_1
XFILLER_58_706 VPWR VGND sg13g2_fill_1
X_6153_ _6246_/D _6408_/B _9232_/Q _8474_/B _6153_/D VPWR VGND sg13g2_nand4_1
XFILLER_112_696 VPWR VGND sg13g2_decap_8
XFILLER_85_514 VPWR VGND sg13g2_decap_4
X_5104_ _5104_/X _5119_/B _5104_/B VPWR VGND sg13g2_or2_1
X_6084_ _6084_/Y _6373_/A1 _6373_/A2 _6084_/B1 VPWR VGND sg13g2_a21oi_1
X_5035_ _5035_/Y _9408_/Q _6534_/C VPWR VGND sg13g2_nand2b_1
XFILLER_97_396 VPWR VGND sg13g2_decap_8
XFILLER_57_249 VPWR VGND sg13g2_decap_8
XFILLER_38_430 VPWR VGND sg13g2_decap_8
XFILLER_66_761 VPWR VGND sg13g2_fill_1
XFILLER_81_753 VPWR VGND sg13g2_fill_1
X_6986_ _6987_/D _7690_/A _7741_/B _8829_/Q VPWR VGND sg13g2_nor3_1
XFILLER_15_14 VPWR VGND sg13g2_fill_1
X_5937_ _5937_/Y _5932_/D _5932_/B _5929_/B _5937_/B2 VPWR VGND sg13g2_a22oi_1
X_8725_ _8725_/Q _9678_/CLK _8725_/D fanout966/X VPWR VGND sg13g2_dfrbpq_1
XFILLER_15_25 VPWR VGND sg13g2_fill_1
XFILLER_34_680 VPWR VGND sg13g2_decap_4
X_8656_ _8656_/Q _9701_/CLK _8656_/D fanout959/X VPWR VGND sg13g2_dfrbpq_1
XFILLER_40_149 VPWR VGND sg13g2_decap_8
X_5868_ _5868_/Y _5939_/A _5865_/X _5933_/C VPWR VGND sg13g2_o21ai_1
X_7607_ _7611_/B _9039_/Q _7725_/B VPWR VGND sg13g2_nor2_1
X_5799_ _9292_/D _5799_/A VPWR VGND sg13g2_inv_1
X_8587_ _8588_/A _9286_/Q _8587_/A2 _8587_/B1 _9483_/Q VPWR VGND sg13g2_a22oi_1
X_4819_ _4831_/A _8818_/Q _9350_/Q VPWR VGND sg13g2_nor2b_1
X_7538_ _7553_/D _8799_/Q _7660_/A2 _7809_/B1 _7538_/B2 VPWR VGND sg13g2_a22oi_1
X_7469_ _7471_/C _7469_/A _9001_/Q _7820_/C VPWR VGND sg13g2_nor3_1
X_9208_ _9208_/Q _9672_/CLK _9208_/D place2450/X VPWR VGND sg13g2_dfrbpq_1
Xplace2460 place2460/X place2488/X VPWR VGND sg13g2_buf_1
Xplace2482 place2482/X place2486/X VPWR VGND sg13g2_buf_1
Xplace2471 place2471/X place2472/X VPWR VGND sg13g2_buf_1
Xplace1781 _8343_/B _8345_/B VPWR VGND sg13g2_buf_1
Xplace1770 _7059_/A _7056_/A VPWR VGND sg13g2_buf_1
Xplace2493 place2493/X place2506/X VPWR VGND sg13g2_buf_1
Xplace1792 _8587_/B1 _5787_/Y VPWR VGND sg13g2_buf_1
Xhold3151 _6660_/A _9450_/Q VPWR VGND sg13g2_dlygate4sd3_1
X_9139_ _9139_/Q _9198_/CLK _9139_/D place2437/X VPWR VGND sg13g2_dfrbpq_1
Xhold3140 _8253_/A _9127_/Q VPWR VGND sg13g2_dlygate4sd3_1
Xhold3173 _7030_/A _8831_/Q VPWR VGND sg13g2_dlygate4sd3_1
XFILLER_76_503 VPWR VGND sg13g2_fill_1
Xhold3162 _8325_/A _9163_/Q VPWR VGND sg13g2_dlygate4sd3_1
Xhold3184 _8315_/A _9158_/Q VPWR VGND sg13g2_dlygate4sd3_1
XFILLER_48_205 VPWR VGND sg13g2_decap_8
Xhold3195 _8036_/A _9027_/Q VPWR VGND sg13g2_dlygate4sd3_1
XFILLER_48_238 VPWR VGND sg13g2_decap_8
XFILLER_63_219 VPWR VGND sg13g2_decap_4
XFILLER_56_65 VPWR VGND sg13g2_decap_8
XFILLER_72_720 VPWR VGND sg13g2_decap_4
XFILLER_56_98 VPWR VGND sg13g2_decap_8
XFILLER_16_102 VPWR VGND sg13g2_fill_1
XFILLER_72_764 VPWR VGND sg13g2_fill_1
XFILLER_16_135 VPWR VGND sg13g2_decap_8
XFILLER_112_71 VPWR VGND sg13g2_decap_8
XFILLER_31_105 VPWR VGND sg13g2_fill_1
XFILLER_9_802 VPWR VGND sg13g2_fill_2
XFILLER_31_149 VPWR VGND sg13g2_fill_1
XFILLER_12_385 VPWR VGND sg13g2_fill_1
Xoutput2719 master_wdata_o[29] _5778_/X VPWR VGND sg13g2_buf_1
Xoutput2708 master_wdata_o[19] _5756_/Y VPWR VGND sg13g2_buf_1
XFILLER_113_416 VPWR VGND sg13g2_fill_2
XFILLER_4_573 VPWR VGND sg13g2_fill_1
XFILLER_94_322 VPWR VGND sg13g2_decap_8
XFILLER_39_227 VPWR VGND sg13g2_decap_4
XFILLER_94_366 VPWR VGND sg13g2_fill_1
XFILLER_55_709 VPWR VGND sg13g2_fill_2
XFILLER_48_772 VPWR VGND sg13g2_decap_8
XFILLER_48_750 VPWR VGND sg13g2_fill_2
XFILLER_75_591 VPWR VGND sg13g2_decap_8
X_6840_ _9588_/D _9621_/Q _9588_/Q _6840_/S VPWR VGND sg13g2_mux2_1
XFILLER_35_455 VPWR VGND sg13g2_decap_8
X_6771_ _9530_/D _9530_/Q _9440_/Q _6779_/S VPWR VGND sg13g2_mux2_1
XFILLER_63_797 VPWR VGND sg13g2_fill_1
X_5722_ _5722_/Y _5762_/A1 _5740_/A2 _5720_/Y _5721_/Y VPWR VGND sg13g2_a22oi_1
X_8510_ _8511_/C _8510_/A _8510_/B VPWR VGND sg13g2_xor2_1
XFILLER_50_436 VPWR VGND sg13g2_decap_4
X_9490_ _9490_/Q _9621_/CLK _9490_/D _9490_/RESET_B VPWR VGND sg13g2_dfrbpq_1
X_5653_ _5653_/Y _5653_/A _5660_/B VPWR VGND sg13g2_nor2_1
X_8441_ _9225_/D _8448_/A _5371_/C _8440_/Y VPWR VGND sg13g2_o21ai_1
XFILLER_117_700 VPWR VGND sg13g2_decap_4
X_5584_ _8649_/D _5583_/Y _5582_/Y _5587_/B1 VPWR VGND sg13g2_a21oi_1
X_4604_ _4604_/Y _9552_/Q _9551_/Q VPWR VGND sg13g2_nand2b_1
X_8372_ _9186_/D _5354_/C _8375_/A _8371_/Y VPWR VGND sg13g2_o21ai_1
XFILLER_117_744 VPWR VGND sg13g2_fill_2
X_4535_ _4560_/B _7245_/B _9467_/Q _9470_/Q _7244_/A VPWR VGND sg13g2_nor4_1
X_7323_ _7323_/Y _8787_/Q _7301_/B _7579_/A2 _8836_/Q _7322_/Y VPWR VGND sg13g2_a221oi_1
XFILLER_116_243 VPWR VGND sg13g2_decap_8
XFILLER_104_416 VPWR VGND sg13g2_fill_2
X_4466_ _9682_/D _6951_/B _4466_/A2 _4465_/Y VPWR VGND sg13g2_a21oi_1
X_7254_ _7258_/A _7278_/C _9114_/Q _7295_/C VPWR VGND sg13g2_nor3_1
X_6205_ _9359_/D _6491_/A2 _6203_/Y _6204_/Y VPWR VGND sg13g2_a21oi_1
X_7185_ _8879_/D _7184_/Y _8879_/Q _7185_/S VPWR VGND sg13g2_mux2_1
X_4397_ _8673_/D _4397_/A _5438_/B_N VPWR VGND sg13g2_nor2b_1
X_6136_ _6136_/Y _6158_/A _6410_/C _6136_/C _6173_/C VPWR VGND sg13g2_nor4_1
XFILLER_73_506 VPWR VGND sg13g2_fill_1
X_6067_ _6067_/X _6067_/A _6073_/B VPWR VGND sg13g2_and2_1
XFILLER_39_750 VPWR VGND sg13g2_fill_2
XFILLER_85_399 VPWR VGND sg13g2_decap_8
XFILLER_73_528 VPWR VGND sg13g2_decap_8
X_5018_ _5018_/Y _5015_/Y _5017_/Y _4957_/D VPWR VGND sg13g2_a21oi_1
XFILLER_26_422 VPWR VGND sg13g2_fill_1
XFILLER_38_271 VPWR VGND sg13g2_decap_8
X_6969_ _6969_/Y _6979_/A _7221_/B _7123_/C VPWR VGND sg13g2_nand3_1
XFILLER_41_458 VPWR VGND sg13g2_fill_1
X_8708_ _8708_/Q _9449_/CLK _8708_/D fanout976/X VPWR VGND sg13g2_dfrbpq_1
X_9688_ _9688_/Q _9689_/CLK _9688_/D fanout964/X VPWR VGND sg13g2_dfrbpq_1
X_8639_ _8639_/Q _9449_/CLK _8639_/D fanout970/X VPWR VGND sg13g2_dfrbpq_1
XFILLER_42_56 VPWR VGND sg13g2_decap_8
XFILLER_107_232 VPWR VGND sg13g2_fill_2
XFILLER_123_725 VPWR VGND sg13g2_fill_2
XFILLER_123_714 VPWR VGND sg13g2_decap_8
Xplace2290 _4999_/B _4945_/A VPWR VGND sg13g2_buf_1
XFILLER_3_28 VPWR VGND sg13g2_decap_8
XFILLER_95_119 VPWR VGND sg13g2_decap_4
XFILLER_95_108 VPWR VGND sg13g2_fill_2
XFILLER_76_300 VPWR VGND sg13g2_decap_8
XFILLER_88_193 VPWR VGND sg13g2_decap_8
XFILLER_88_182 VPWR VGND sg13g2_fill_2
XFILLER_88_171 VPWR VGND sg13g2_decap_8
XFILLER_76_366 VPWR VGND sg13g2_fill_2
XFILLER_37_709 VPWR VGND sg13g2_decap_8
XFILLER_123_70 VPWR VGND sg13g2_decap_8
XFILLER_29_282 VPWR VGND sg13g2_fill_2
XFILLER_45_720 VPWR VGND sg13g2_decap_8
XFILLER_60_723 VPWR VGND sg13g2_decap_8
XFILLER_17_477 VPWR VGND sg13g2_decap_4
XFILLER_17_488 VPWR VGND sg13g2_fill_1
XFILLER_80_7 VPWR VGND sg13g2_fill_2
XFILLER_12_171 VPWR VGND sg13g2_fill_1
XFILLER_9_632 VPWR VGND sg13g2_fill_2
XFILLER_13_694 VPWR VGND sg13g2_decap_8
XFILLER_8_175 VPWR VGND sg13g2_fill_1
XFILLER_114_736 VPWR VGND sg13g2_decap_8
XFILLER_113_202 VPWR VGND sg13g2_fill_2
X_4320_ _4320_/Y _9871_/A VPWR VGND sg13g2_inv_1
XFILLER_4_370 VPWR VGND sg13g2_fill_1
XFILLER_113_268 VPWR VGND sg13g2_decap_4
XFILLER_83_804 VPWR VGND sg13g2_fill_1
X_8990_ _8990_/Q _9242_/CLK _8990_/D place2494/X VPWR VGND sg13g2_dfrbpq_1
XFILLER_103_29 VPWR VGND sg13g2_fill_2
X_7941_ _8982_/D _5367_/C _7950_/A _7940_/Y VPWR VGND sg13g2_o21ai_1
X_7872_ _8945_/D _7596_/Y _7883_/S _7871_/Y VPWR VGND sg13g2_a21oi_1
XFILLER_82_358 VPWR VGND sg13g2_decap_4
X_9611_ _9611_/Q _9611_/CLK _9611_/D _9611_/RESET_B VPWR VGND sg13g2_dfrbpq_1
XFILLER_63_550 VPWR VGND sg13g2_decap_8
X_6823_ _9571_/D _9604_/Q _9571_/Q _6836_/S VPWR VGND sg13g2_mux2_1
XFILLER_50_233 VPWR VGND sg13g2_decap_8
X_6754_ _9513_/D _9513_/Q _9423_/Q _6783_/S VPWR VGND sg13g2_mux2_1
X_9542_ _9542_/Q _9686_/CLK _9542_/D _9542_/RESET_B VPWR VGND sg13g2_dfrbpq_1
XFILLER_51_789 VPWR VGND sg13g2_fill_1
XFILLER_50_244 VPWR VGND sg13g2_fill_2
X_6685_ _6685_/Y _9662_/Q _9660_/Q _9659_/Q _9657_/Q VPWR VGND sg13g2_nor4_1
X_5705_ _5706_/B _9651_/Q _9652_/Q VPWR VGND sg13g2_or2_1
X_9473_ _9473_/Q clkload6/A _9473_/D _9473_/RESET_B VPWR VGND sg13g2_dfrbpq_1
XFILLER_50_288 VPWR VGND sg13g2_decap_4
XFILLER_31_480 VPWR VGND sg13g2_decap_8
X_8424_ _8424_/Y _8432_/A _9216_/Q _8430_/C VPWR VGND sg13g2_nand3_1
X_5636_ _5637_/A _5639_/B1 _5699_/A2 _5699_/B1 _5636_/B2 VPWR VGND sg13g2_a22oi_1
X_5567_ _5567_/Y _9442_/Q _5570_/B VPWR VGND sg13g2_nand2_1
XFILLER_105_703 VPWR VGND sg13g2_decap_8
X_8355_ _8355_/Y _8355_/A _9178_/Q _8355_/C VPWR VGND sg13g2_nand3_1
XFILLER_105_714 VPWR VGND sg13g2_fill_1
X_7306_ _7306_/Y _7459_/A _7306_/B VPWR VGND sg13g2_nor2_1
X_5498_ _5498_/X _5625_/B _6541_/A _6541_/B VPWR VGND sg13g2_and3_1
X_4518_ _4518_/Y _6015_/B _4518_/B _5392_/C _5392_/D VPWR VGND sg13g2_nand4_1
X_8286_ _9143_/D _8286_/A1 _7954_/Y _8285_/Y VPWR VGND sg13g2_o21ai_1
XFILLER_105_769 VPWR VGND sg13g2_fill_1
X_7237_ _7237_/Y _7237_/A1 _9501_/Q _7237_/B1 _7237_/B2 VPWR VGND sg13g2_a22oi_1
X_4449_ _4518_/B _6046_/A _6071_/B _7187_/A _6037_/A VPWR VGND sg13g2_nor4_1
XFILLER_120_728 VPWR VGND sg13g2_decap_8
XFILLER_120_717 VPWR VGND sg13g2_fill_1
X_7168_ _7168_/Y _7187_/A _7168_/B _7236_/C _7168_/D VPWR VGND sg13g2_nand4_1
XFILLER_100_452 VPWR VGND sg13g2_decap_8
XFILLER_86_653 VPWR VGND sg13g2_fill_1
XFILLER_85_141 VPWR VGND sg13g2_decap_8
XFILLER_58_344 VPWR VGND sg13g2_fill_1
X_7099_ _7099_/Y _7201_/A _7210_/D _7105_/C VPWR VGND sg13g2_nand3_1
X_6119_ _6119_/X _8964_/Q _9026_/Q _9088_/Q _9150_/Q _6381_/S0 _6363_/S1 VPWR VGND
+ sg13g2_mux4_1
XFILLER_46_506 VPWR VGND sg13g2_decap_4
XFILLER_73_325 VPWR VGND sg13g2_fill_1
XFILLER_37_67 VPWR VGND sg13g2_decap_4
XFILLER_46_528 VPWR VGND sg13g2_decap_8
XFILLER_46_539 VPWR VGND sg13g2_fill_1
XFILLER_27_753 VPWR VGND sg13g2_decap_8
XFILLER_54_550 VPWR VGND sg13g2_fill_1
XFILLER_26_285 VPWR VGND sg13g2_fill_2
XFILLER_42_767 VPWR VGND sg13g2_fill_2
XFILLER_108_530 VPWR VGND sg13g2_decap_8
XFILLER_6_646 VPWR VGND sg13g2_decap_8
XFILLER_5_167 VPWR VGND sg13g2_decap_8
XRVDBG4614 slave_gnt_o VPWR VGND sg13g2_tiehi
XFILLER_78_96 VPWR VGND sg13g2_decap_8
XFILLER_65_804 VPWR VGND sg13g2_fill_1
XFILLER_49_366 VPWR VGND sg13g2_fill_2
XFILLER_37_506 VPWR VGND sg13g2_decap_8
XFILLER_64_314 VPWR VGND sg13g2_decap_8
Xclkbuf_leaf_1_jtag_tck_i_regs _9701_/CLK clkbuf_leaf_1_jtag_tck_i_regs/A VPWR VGND
+ sg13g2_buf_16
XFILLER_18_731 VPWR VGND sg13g2_fill_2
XFILLER_17_263 VPWR VGND sg13g2_fill_1
XFILLER_18_764 VPWR VGND sg13g2_fill_1
XFILLER_72_380 VPWR VGND sg13g2_decap_8
XFILLER_33_756 VPWR VGND sg13g2_decap_8
XFILLER_20_417 VPWR VGND sg13g2_fill_1
XFILLER_20_428 VPWR VGND sg13g2_fill_1
XFILLER_20_439 VPWR VGND sg13g2_fill_1
X_6470_ _6470_/Y _6312_/C _6470_/A2 _6470_/B1 VPWR VGND sg13g2_a21oi_1
XFILLER_9_473 VPWR VGND sg13g2_fill_2
X_5421_ _8663_/D _5417_/Y _5419_/Y _5420_/Y VPWR VGND sg13g2_a21oi_1
X_5352_ _8792_/D _5360_/A _5360_/B _5352_/C _5360_/D VPWR VGND sg13g2_nor4_1
X_8140_ _9070_/D _8160_/A1 _8068_/Y _8139_/Y VPWR VGND sg13g2_o21ai_1
X_8071_ _8071_/Y _8403_/C _9490_/Q _8498_/D _8083_/D VPWR VGND sg13g2_nand4_1
X_4303_ _5343_/B _9464_/Q VPWR VGND sg13g2_inv_1
XFILLER_99_277 VPWR VGND sg13g2_decap_4
XFILLER_87_417 VPWR VGND sg13g2_decap_8
X_5283_ _5367_/C _8389_/C _9494_/Q VPWR VGND sg13g2_nand2_1
X_7022_ _7022_/Y _7022_/A _8221_/B VPWR VGND sg13g2_nand2_1
XFILLER_4_60 VPWR VGND sg13g2_fill_2
XFILLER_68_631 VPWR VGND sg13g2_decap_8
XFILLER_110_761 VPWR VGND sg13g2_fill_1
XFILLER_83_601 VPWR VGND sg13g2_fill_1
XFILLER_82_144 VPWR VGND sg13g2_decap_8
X_8973_ _8973_/Q clkload8/A _8973_/D place2465/X VPWR VGND sg13g2_dfrbpq_1
XFILLER_24_712 VPWR VGND sg13g2_decap_8
X_7924_ _7924_/Y _7924_/A _8975_/Q _8383_/C VPWR VGND sg13g2_nand3_1
XFILLER_70_339 VPWR VGND sg13g2_decap_8
X_7855_ _8932_/D _8932_/Q _7342_/Y _7885_/S VPWR VGND sg13g2_mux2_1
X_6806_ _6806_/Y _9555_/Q _8726_/Q _8725_/Q VPWR VGND sg13g2_o21ai_1
X_9525_ _9525_/Q _9567_/CLK _9525_/D _9525_/RESET_B VPWR VGND sg13g2_dfrbpq_1
X_7786_ _7791_/A _7780_/Y _7785_/Y _8083_/D VPWR VGND sg13g2_o21ai_1
XFILLER_51_575 VPWR VGND sg13g2_decap_8
XFILLER_11_439 VPWR VGND sg13g2_fill_1
XFILLER_11_428 VPWR VGND sg13g2_decap_8
XFILLER_23_277 VPWR VGND sg13g2_decap_4
X_4998_ _4999_/A _4998_/A _4998_/B VPWR VGND sg13g2_nand2_1
X_6737_ _6737_/Y _6737_/A _6737_/B _6737_/C VPWR VGND sg13g2_nand3_1
X_9456_ _9456_/Q _9649_/CLK _9456_/D fanout977/X VPWR VGND sg13g2_dfrbpq_1
X_6668_ _6668_/Y _9452_/Q _6671_/B VPWR VGND sg13g2_nand2_1
X_6599_ _9431_/D _6663_/A1 _6598_/Y _6597_/Y VPWR VGND sg13g2_o21ai_1
X_8407_ _8407_/Y _8407_/A _9204_/Q _8407_/C VPWR VGND sg13g2_nand3_1
X_5619_ _5619_/Y _9420_/Q _5621_/B _5500_/Y _8661_/Q VPWR VGND sg13g2_a22oi_1
X_9387_ _9387_/Q _9406_/CLK _9387_/D place2491/X VPWR VGND sg13g2_dfrbpq_1
XFILLER_105_511 VPWR VGND sg13g2_decap_8
X_8338_ _9169_/D _8344_/A1 _8086_/Y _8337_/Y VPWR VGND sg13g2_o21ai_1
XFILLER_117_382 VPWR VGND sg13g2_fill_2
X_8269_ _8269_/Y _8269_/A _8285_/B VPWR VGND sg13g2_nand2_1
XFILLER_73_100 VPWR VGND sg13g2_fill_2
XFILLER_58_152 VPWR VGND sg13g2_decap_8
XFILLER_19_539 VPWR VGND sg13g2_decap_8
XFILLER_100_282 VPWR VGND sg13g2_decap_8
XFILLER_86_494 VPWR VGND sg13g2_decap_8
XFILLER_104_94 VPWR VGND sg13g2_decap_4
XFILLER_27_561 VPWR VGND sg13g2_decap_8
XFILLER_64_65 VPWR VGND sg13g2_fill_2
XFILLER_54_391 VPWR VGND sg13g2_decap_8
XFILLER_120_71 VPWR VGND sg13g2_decap_8
XFILLER_9_49 VPWR VGND sg13g2_fill_2
XFILLER_30_726 VPWR VGND sg13g2_decap_8
XFILLER_80_97 VPWR VGND sg13g2_fill_2
XFILLER_6_454 VPWR VGND sg13g2_decap_8
XFILLER_6_476 VPWR VGND sg13g2_fill_2
XFILLER_108_382 VPWR VGND sg13g2_fill_2
XFILLER_123_385 VPWR VGND sg13g2_decap_8
XFILLER_49_141 VPWR VGND sg13g2_decap_8
XFILLER_77_483 VPWR VGND sg13g2_fill_1
XFILLER_65_612 VPWR VGND sg13g2_decap_8
XFILLER_64_100 VPWR VGND sg13g2_decap_8
XFILLER_49_185 VPWR VGND sg13g2_fill_1
X_5970_ _9325_/D _5981_/B _5968_/Y _5969_/Y VPWR VGND sg13g2_o21ai_1
XFILLER_92_464 VPWR VGND sg13g2_decap_8
X_4921_ _4921_/Y _5000_/B1 _5012_/B _4920_/Y VPWR VGND sg13g2_o21ai_1
XFILLER_33_520 VPWR VGND sg13g2_decap_8
X_7640_ _7641_/B _9878_/A _7640_/A2 _7846_/A2 _8853_/Q VPWR VGND sg13g2_a22oi_1
X_4852_ _4854_/B _9385_/Q _4853_/A VPWR VGND sg13g2_nor2b_1
XFILLER_33_564 VPWR VGND sg13g2_decap_8
XFILLER_21_737 VPWR VGND sg13g2_decap_4
XFILLER_33_597 VPWR VGND sg13g2_fill_2
X_7571_ _7574_/B _7565_/Y _7570_/Y _7571_/B1 VPWR VGND sg13g2_o21ai_1
X_4783_ _4935_/A _4999_/B _4783_/B _4783_/C _4816_/B VPWR VGND sg13g2_nand4_1
X_9310_ _9310_/Q _9410_/CLK _9310_/D place2406/X VPWR VGND sg13g2_dfrbpq_1
X_6522_ _6523_/D _9264_/Q _9263_/Q _9265_/Q VPWR VGND sg13g2_nor3_1
XFILLER_119_669 VPWR VGND sg13g2_fill_1
XFILLER_119_658 VPWR VGND sg13g2_decap_8
XFILLER_118_146 VPWR VGND sg13g2_fill_1
XFILLER_9_281 VPWR VGND sg13g2_fill_2
X_6453_ _6453_/Y _6510_/B _6399_/A _6452_/Y VPWR VGND sg13g2_o21ai_1
X_9241_ _9241_/Q _9251_/CLK _9241_/D place2481/X VPWR VGND sg13g2_dfrbpq_1
X_5404_ _5404_/Y _5404_/A _8515_/A _5404_/C _8515_/B VPWR VGND sg13g2_nand4_1
X_9172_ _9172_/Q _9198_/CLK _9172_/D place2436/X VPWR VGND sg13g2_dfrbpq_1
X_8123_ _8123_/Y _8123_/A _8129_/B VPWR VGND sg13g2_nand2_1
X_6384_ _9384_/D _6383_/Y _9384_/Q _6392_/S VPWR VGND sg13g2_mux2_1
XFILLER_114_363 VPWR VGND sg13g2_decap_4
XFILLER_102_503 VPWR VGND sg13g2_decap_8
X_5335_ _5335_/Y _5335_/A _5338_/A VPWR VGND sg13g2_nand2_1
X_5266_ _5268_/B _5272_/A _5291_/B _5291_/C _9878_/A VPWR VGND sg13g2_nand4_1
X_8054_ _9033_/D _8054_/A1 _8053_/Y _8052_/Y VPWR VGND sg13g2_o21ai_1
X_9502__2878 _9502_/RESET_B VPWR VGND sg13g2_tiehi
XFILLER_87_269 VPWR VGND sg13g2_decap_8
X_7005_ _7934_/A _8498_/C _7010_/A _7032_/C _7032_/D VPWR VGND sg13g2_nand4_1
XFILLER_55_100 VPWR VGND sg13g2_fill_1
X_5197_ _5353_/C _6959_/B _9480_/Q VPWR VGND sg13g2_nand2_1
X_8956_ _8956_/Q _9611_/CLK _8956_/D place2416/X VPWR VGND sg13g2_dfrbpq_1
XFILLER_83_475 VPWR VGND sg13g2_decap_8
XFILLER_83_453 VPWR VGND sg13g2_fill_2
XFILLER_43_306 VPWR VGND sg13g2_decap_4
XFILLER_43_317 VPWR VGND sg13g2_fill_2
X_7907_ _8967_/D _5352_/C _7924_/A _7906_/Y VPWR VGND sg13g2_o21ai_1
XFILLER_70_158 VPWR VGND sg13g2_decap_8
X_8887_ _8887_/Q _9253_/CLK _8887_/D place2426/X VPWR VGND sg13g2_dfrbpq_1
XFILLER_24_575 VPWR VGND sg13g2_decap_8
X_7838_ _7841_/C _9051_/Q _7838_/B VPWR VGND sg13g2_nor2_1
X_7769_ _7772_/B _7763_/Y _7768_/Y _8083_/D VPWR VGND sg13g2_o21ai_1
XFILLER_11_247 VPWR VGND sg13g2_fill_1
XFILLER_50_12 VPWR VGND sg13g2_decap_8
Xclkload1 clkload1/X clkload1/A VPWR VGND sg13g2_buf_16
X_9508_ _9508_/Q _9511_/CLK _9508_/D _9508_/RESET_B VPWR VGND sg13g2_dfrbpq_1
X_9439_ _9439_/Q _9567_/CLK _9439_/D fanout983/X VPWR VGND sg13g2_dfrbpq_1
XFILLER_109_124 VPWR VGND sg13g2_fill_2
XFILLER_3_402 VPWR VGND sg13g2_fill_1
XFILLER_105_341 VPWR VGND sg13g2_decap_8
XFILLER_79_704 VPWR VGND sg13g2_decap_8
XFILLER_3_457 VPWR VGND sg13g2_decap_8
XFILLER_120_322 VPWR VGND sg13g2_decap_8
XFILLER_79_737 VPWR VGND sg13g2_fill_1
XFILLER_59_494 VPWR VGND sg13g2_decap_8
XFILLER_47_678 VPWR VGND sg13g2_decap_8
XFILLER_74_486 VPWR VGND sg13g2_decap_8
XFILLER_61_169 VPWR VGND sg13g2_decap_4
XFILLER_15_553 VPWR VGND sg13g2_fill_1
XFILLER_30_578 VPWR VGND sg13g2_decap_8
Xplace2108 _7695_/A2 _8413_/B VPWR VGND sg13g2_buf_1
XFILLER_7_752 VPWR VGND sg13g2_decap_4
Xplace2119 _8120_/A1 _7017_/Y VPWR VGND sg13g2_buf_1
XFILLER_109_691 VPWR VGND sg13g2_decap_8
XFILLER_111_311 VPWR VGND sg13g2_decap_8
X_5120_ _5120_/Y _5120_/A _5120_/B VPWR VGND sg13g2_xnor2_1
X_5051_ _5051_/Y _5124_/A _5096_/C _9859_/A _5110_/A VPWR VGND sg13g2_nand4_1
XFILLER_85_707 VPWR VGND sg13g2_decap_8
XFILLER_84_239 VPWR VGND sg13g2_fill_2
XFILLER_65_442 VPWR VGND sg13g2_fill_2
X_8810_ _8810_/Q _9219_/CLK _8810_/D place2408/X VPWR VGND sg13g2_dfrbpq_1
XFILLER_80_401 VPWR VGND sg13g2_decap_8
XFILLER_65_453 VPWR VGND sg13g2_decap_8
X_8741_ _8741_/Q _9686_/CLK _8741_/D fanout964/X VPWR VGND sg13g2_dfrbpq_1
X_5953_ _5953_/Y _5932_/D _5932_/B _5929_/B _5953_/B2 VPWR VGND sg13g2_a22oi_1
X_5884_ _5884_/Y _5939_/A _5881_/X _5933_/C VPWR VGND sg13g2_o21ai_1
X_4904_ _4904_/Y _4902_/Y _4903_/Y _5006_/A1 VPWR VGND sg13g2_a21oi_1
X_8672_ _8672_/Q _8678_/CLK _8672_/D fanout943/X VPWR VGND sg13g2_dfrbpq_1
X_7623_ _7625_/C _9164_/Q _7767_/B VPWR VGND sg13g2_nor2_1
XFILLER_21_556 VPWR VGND sg13g2_decap_8
X_4835_ _4835_/Y _4834_/Y _4812_/Y _4899_/C VPWR VGND sg13g2_a21oi_1
X_7554_ _7555_/B _9289_/Q _7828_/A2 _7788_/B1 _8848_/Q _7553_/Y VPWR VGND sg13g2_a221oi_1
XFILLER_21_589 VPWR VGND sg13g2_decap_8
X_4766_ _4983_/B _4766_/A _4903_/A VPWR VGND sg13g2_nand2_1
X_6505_ _9405_/D _6503_/Y _6505_/A2 _6504_/Y VPWR VGND sg13g2_a21oi_1
XFILLER_119_477 VPWR VGND sg13g2_decap_8
X_4697_ _4697_/Y _9672_/Q _8739_/Q _9675_/Q _6955_/S VPWR VGND sg13g2_a22oi_1
X_7485_ _7489_/B _9064_/Q _7485_/B VPWR VGND sg13g2_nor2_1
X_6436_ _9395_/D _6505_/A2 _6434_/Y _6435_/Y VPWR VGND sg13g2_a21oi_1
X_9224_ _9224_/Q _9253_/CLK _9224_/D place2462/X VPWR VGND sg13g2_dfrbpq_1
Xplace1930 _6373_/A2 _6346_/B VPWR VGND sg13g2_buf_1
XFILLER_20_59 VPWR VGND sg13g2_fill_1
Xplace1941 _7598_/B1 _7680_/B1 VPWR VGND sg13g2_buf_1
Xplace1963 _7229_/B2 _7237_/B2 VPWR VGND sg13g2_buf_1
X_6367_ _6367_/Y _6039_/X _6176_/A _6366_/Y VPWR VGND sg13g2_a21oi_1
X_9155_ _9155_/Q _9188_/CLK _9155_/D place2466/X VPWR VGND sg13g2_dfrbpq_1
Xplace1952 _6511_/A2 _6130_/B VPWR VGND sg13g2_buf_1
XFILLER_115_694 VPWR VGND sg13g2_fill_2
X_5318_ _8779_/D _5341_/A1 _5371_/C _5317_/Y _5336_/B2 VPWR VGND sg13g2_a22oi_1
Xplace1985 _7771_/A2 _5383_/Y VPWR VGND sg13g2_buf_1
Xplace1996 _7520_/B _5380_/Y VPWR VGND sg13g2_buf_1
Xplace1974 _8288_/A1 _8284_/A1 VPWR VGND sg13g2_buf_1
X_8106_ _9053_/D _8130_/A1 _7889_/Y _8105_/Y VPWR VGND sg13g2_o21ai_1
XFILLER_114_182 VPWR VGND sg13g2_fill_1
X_9086_ _9086_/Q _9183_/CLK _9086_/D place2469/X VPWR VGND sg13g2_dfrbpq_1
XFILLER_0_438 VPWR VGND sg13g2_decap_8
X_6298_ _6298_/Y _9237_/Q _6144_/D _6509_/B VPWR VGND sg13g2_o21ai_1
X_5249_ _5249_/Y _5334_/A _5255_/B _5288_/A1 VPWR VGND sg13g2_a21oi_1
X_8037_ _9027_/D _8100_/A1 _7902_/Y _8036_/Y VPWR VGND sg13g2_o21ai_1
XFILLER_56_497 VPWR VGND sg13g2_decap_8
XFILLER_44_637 VPWR VGND sg13g2_fill_2
X_8939_ _8939_/Q _9504_/CLK _8939_/D place2428/X VPWR VGND sg13g2_dfrbpq_1
XFILLER_101_62 VPWR VGND sg13g2_decap_8
Xinput2542 _7473_/B2 hartinfo_i[11] VPWR VGND sg13g2_buf_1
XFILLER_61_77 VPWR VGND sg13g2_decap_4
XFILLER_12_567 VPWR VGND sg13g2_decap_8
Xinput2586 _5907_/A1 master_rdata_i[17] VPWR VGND sg13g2_buf_1
Xinput2575 _8530_/C master_err_i VPWR VGND sg13g2_buf_1
Xinput2564 _6999_/B2 hartinfo_i[31] VPWR VGND sg13g2_buf_1
Xinput2553 _7659_/B2 hartinfo_i[21] VPWR VGND sg13g2_buf_1
XFILLER_8_538 VPWR VGND sg13g2_fill_1
Xinput2597 _5992_/A master_rdata_i[27] VPWR VGND sg13g2_buf_1
XFILLER_117_0 VPWR VGND sg13g2_decap_4
XFILLER_6_28 VPWR VGND sg13g2_decap_8
XFILLER_106_661 VPWR VGND sg13g2_decap_8
XFILLER_79_523 VPWR VGND sg13g2_decap_8
XFILLER_10_81 VPWR VGND sg13g2_fill_2
XFILLER_4_799 VPWR VGND sg13g2_fill_2
XFILLER_3_265 VPWR VGND sg13g2_decap_8
XFILLER_121_631 VPWR VGND sg13g2_fill_2
XFILLER_10_92 VPWR VGND sg13g2_decap_4
XFILLER_66_206 VPWR VGND sg13g2_decap_8
XFILLER_19_144 VPWR VGND sg13g2_decap_8
XFILLER_35_615 VPWR VGND sg13g2_decap_8
XFILLER_35_626 VPWR VGND sg13g2_decap_8
X_9606__2784 _9606_/RESET_B VPWR VGND sg13g2_tiehi
XFILLER_90_776 VPWR VGND sg13g2_decap_8
XFILLER_74_294 VPWR VGND sg13g2_fill_1
XFILLER_90_787 VPWR VGND sg13g2_fill_1
XFILLER_30_331 VPWR VGND sg13g2_fill_2
X_4620_ _4621_/C _9207_/Q _9684_/Q _9687_/Q _9686_/Q VPWR VGND sg13g2_nor4_1
XFILLER_116_403 VPWR VGND sg13g2_decap_8
X_4551_ _4554_/A _9218_/Q _7461_/C VPWR VGND sg13g2_nand2_1
X_4482_ _9653_/D _4687_/A _4482_/B VPWR VGND sg13g2_nor2_1
X_7270_ _7455_/C _8498_/B _7482_/C VPWR VGND sg13g2_nand2_1
XFILLER_7_582 VPWR VGND sg13g2_fill_1
XFILLER_104_609 VPWR VGND sg13g2_fill_2
X_6221_ _6221_/Y _6504_/A1 _6463_/A2 _6221_/B1 VPWR VGND sg13g2_a21oi_1
X_6152_ _6152_/Y _6150_/Y _6151_/Y _6044_/C VPWR VGND sg13g2_a21oi_1
X_5103_ _5104_/B _5134_/A _5101_/Y _5090_/B _5090_/A VPWR VGND sg13g2_a22oi_1
XFILLER_32_0 VPWR VGND sg13g2_fill_2
XFILLER_112_675 VPWR VGND sg13g2_decap_4
XFILLER_97_364 VPWR VGND sg13g2_decap_8
X_6083_ _9346_/D _6131_/D _6082_/Y _6075_/Y VPWR VGND sg13g2_a21oi_1
X_5034_ _5057_/A _9408_/Q _9409_/Q VPWR VGND sg13g2_nor2_1
XFILLER_85_559 VPWR VGND sg13g2_fill_1
XFILLER_122_28 VPWR VGND sg13g2_decap_8
XFILLER_72_209 VPWR VGND sg13g2_fill_1
XFILLER_81_765 VPWR VGND sg13g2_fill_1
X_6985_ _6987_/A _7690_/A _8830_/Q _7747_/C VPWR VGND sg13g2_nor3_1
X_5936_ _5936_/Y _5945_/A _5936_/B VPWR VGND sg13g2_nand2_1
X_8724_ _8724_/Q _9678_/CLK _8724_/D fanout966/X VPWR VGND sg13g2_dfrbpq_1
X_8655_ _8655_/Q _9645_/CLK _8655_/D fanout968/X VPWR VGND sg13g2_dfrbpq_1
X_5867_ _5867_/Y _5891_/A1 _5906_/A2 _5867_/B1 _5891_/B2 VPWR VGND sg13g2_a22oi_1
X_7606_ _7606_/Y _7606_/A _7606_/B _7606_/C _7606_/D VPWR VGND sg13g2_nor4_1
X_5798_ _5799_/A _9292_/Q _8587_/A2 _8587_/B1 _9489_/Q VPWR VGND sg13g2_a22oi_1
X_8586_ _9285_/D _8586_/A VPWR VGND sg13g2_inv_1
XFILLER_21_397 VPWR VGND sg13g2_fill_1
X_4818_ _4818_/Y _4880_/B _4808_/Y _4817_/Y VPWR VGND sg13g2_o21ai_1
X_7537_ _8910_/D _8910_/Q _7536_/Y _7576_/S VPWR VGND sg13g2_mux2_1
X_4749_ _4772_/A _4880_/D _4903_/C _4903_/B VPWR VGND sg13g2_o21ai_1
XFILLER_110_7 VPWR VGND sg13g2_decap_8
X_7468_ _7471_/B _7469_/A _7819_/B _8970_/Q VPWR VGND sg13g2_nor3_1
Xplace2450 place2450/X place2451/X VPWR VGND sg13g2_buf_1
X_6419_ _6419_/Y _6504_/A1 _6463_/A2 _6419_/B1 VPWR VGND sg13g2_a21oi_1
Xplace2483 place2483/X place2486/X VPWR VGND sg13g2_buf_1
Xplace2472 place2472/X place2473/X VPWR VGND sg13g2_buf_1
Xplace2461 place2461/X place2462/X VPWR VGND sg13g2_buf_1
X_9207_ _9207_/Q _9689_/CLK _9207_/D fanout963/X VPWR VGND sg13g2_dfrbpq_1
Xplace1771 _6670_/A1 _6569_/Y VPWR VGND sg13g2_buf_1
X_7399_ _7402_/A _8746_/Q _5412_/C _7598_/B1 _8872_/Q VPWR VGND sg13g2_a22oi_1
XFILLER_0_202 VPWR VGND sg13g2_fill_2
Xplace2494 place2494/X place2495/X VPWR VGND sg13g2_buf_1
XFILLER_115_480 VPWR VGND sg13g2_decap_4
Xplace1793 _5334_/A _5316_/A VPWR VGND sg13g2_buf_1
X_9138_ _9138_/Q _9501_/CLK _9138_/D place2434/X VPWR VGND sg13g2_dfrbpq_1
XFILLER_49_707 VPWR VGND sg13g2_decap_8
Xplace1782 _8347_/B _8299_/B VPWR VGND sg13g2_buf_1
Xhold3130 _8307_/A _9154_/Q VPWR VGND sg13g2_dlygate4sd3_1
Xhold3141 _8049_/A _9032_/Q VPWR VGND sg13g2_dlygate4sd3_1
XFILLER_102_141 VPWR VGND sg13g2_decap_4
Xhold3185 _8203_/A _9102_/Q VPWR VGND sg13g2_dlygate4sd3_1
X_9069_ _9069_/Q _9504_/CLK _9069_/D place2411/X VPWR VGND sg13g2_dfrbpq_1
Xhold3174 _8494_/B _9252_/Q VPWR VGND sg13g2_dlygate4sd3_1
XFILLER_49_729 VPWR VGND sg13g2_fill_2
Xhold3163 _6409_/B1 _9389_/Q VPWR VGND sg13g2_dlygate4sd3_1
Xhold3152 _5667_/B2 _8606_/Q VPWR VGND sg13g2_dlygate4sd3_1
XFILLER_103_697 VPWR VGND sg13g2_decap_4
XFILLER_102_174 VPWR VGND sg13g2_decap_4
XFILLER_88_397 VPWR VGND sg13g2_fill_2
Xhold3196 _8249_/A _9125_/Q VPWR VGND sg13g2_dlygate4sd3_1
XFILLER_16_114 VPWR VGND sg13g2_decap_8
XFILLER_17_626 VPWR VGND sg13g2_fill_1
XFILLER_44_401 VPWR VGND sg13g2_decap_8
XFILLER_44_412 VPWR VGND sg13g2_fill_1
XFILLER_71_253 VPWR VGND sg13g2_fill_2
XFILLER_32_618 VPWR VGND sg13g2_fill_1
XFILLER_31_117 VPWR VGND sg13g2_fill_2
XFILLER_12_342 VPWR VGND sg13g2_decap_8
XFILLER_8_302 VPWR VGND sg13g2_decap_8
XFILLER_12_364 VPWR VGND sg13g2_decap_4
Xoutput2709 master_wdata_o[1] _5710_/X VPWR VGND sg13g2_buf_1
XFILLER_113_439 VPWR VGND sg13g2_fill_1
XFILLER_4_585 VPWR VGND sg13g2_fill_1
XFILLER_106_491 VPWR VGND sg13g2_fill_1
XFILLER_97_51 VPWR VGND sg13g2_decap_8
XFILLER_79_331 VPWR VGND sg13g2_decap_4
XFILLER_79_353 VPWR VGND sg13g2_decap_8
XFILLER_79_397 VPWR VGND sg13g2_decap_4
XFILLER_39_217 VPWR VGND sg13g2_decap_4
XFILLER_82_529 VPWR VGND sg13g2_fill_1
XFILLER_62_242 VPWR VGND sg13g2_fill_1
XFILLER_35_434 VPWR VGND sg13g2_decap_8
X_6770_ _9529_/D _9529_/Q _9439_/Q _6779_/S VPWR VGND sg13g2_mux2_1
XFILLER_62_253 VPWR VGND sg13g2_decap_8
XFILLER_50_415 VPWR VGND sg13g2_decap_8
XFILLER_23_607 VPWR VGND sg13g2_fill_2
XFILLER_23_618 VPWR VGND sg13g2_decap_8
XFILLER_35_478 VPWR VGND sg13g2_decap_8
X_5721_ _5721_/Y _5749_/B _9315_/Q VPWR VGND sg13g2_nand2_1
XFILLER_16_681 VPWR VGND sg13g2_decap_8
X_5652_ _8617_/D _5652_/A VPWR VGND sg13g2_inv_1
X_8440_ _8440_/Y _8448_/A _9225_/Q _8448_/C VPWR VGND sg13g2_nand3_1
X_5583_ _5583_/Y _9447_/Q _5570_/B _5586_/B1 _8649_/Q VPWR VGND sg13g2_a22oi_1
X_4603_ _4606_/A _9550_/Q _9549_/Q _4694_/A VPWR VGND sg13g2_o21ai_1
X_8371_ _8371_/Y _8375_/A _9186_/Q _8371_/C VPWR VGND sg13g2_nand3_1
XFILLER_116_222 VPWR VGND sg13g2_decap_8
X_7322_ _7322_/Y _7322_/A _7322_/B _7322_/C VPWR VGND sg13g2_nand3_1
X_4534_ _7032_/D _9470_/Q _7244_/A VPWR VGND sg13g2_nor2_1
XFILLER_117_756 VPWR VGND sg13g2_decap_4
XFILLER_7_390 VPWR VGND sg13g2_fill_1
XFILLER_104_428 VPWR VGND sg13g2_fill_2
X_7253_ _7253_/Y _7299_/A _7253_/B _7253_/C _7253_/D VPWR VGND sg13g2_nor4_1
X_4465_ _4465_/Y _8742_/Q _9682_/Q _4729_/A VPWR VGND sg13g2_nor3_1
X_6204_ _6204_/Y _6312_/C _6312_/A _6204_/B1 VPWR VGND sg13g2_a21oi_1
X_7184_ _7184_/Y _7238_/A1 _7182_/Y _7183_/Y VPWR VGND sg13g2_a21oi_1
Xfanout804 _6037_/A slave_addr_i[3] VPWR VGND sg13g2_buf_1
X_4396_ _4397_/A _4396_/A1 _5435_/A2 _4395_/Y VPWR VGND sg13g2_a21oi_1
XFILLER_98_662 VPWR VGND sg13g2_fill_2
XFILLER_97_150 VPWR VGND sg13g2_fill_1
XFILLER_86_802 VPWR VGND sg13g2_fill_2
X_6135_ _6173_/C _6262_/A _6262_/B _6509_/D _6262_/C VPWR VGND sg13g2_nand4_1
XFILLER_85_323 VPWR VGND sg13g2_decap_8
XFILLER_58_548 VPWR VGND sg13g2_fill_1
X_6066_ _6067_/A _8833_/Q _6375_/A2 _6042_/Y _6063_/X _6065_/Y VPWR VGND sg13g2_a221oi_1
XFILLER_100_667 VPWR VGND sg13g2_fill_1
X_5017_ _5017_/Y _5017_/A1 _5016_/Y _4875_/Y VPWR VGND sg13g2_o21ai_1
XFILLER_66_570 VPWR VGND sg13g2_fill_2
XFILLER_26_401 VPWR VGND sg13g2_fill_2
XFILLER_14_618 VPWR VGND sg13g2_decap_8
XFILLER_26_467 VPWR VGND sg13g2_fill_1
XFILLER_26_478 VPWR VGND sg13g2_decap_4
XFILLER_41_404 VPWR VGND sg13g2_decap_4
X_8707_ _8707_/Q _9649_/CLK _8707_/D fanout974/X VPWR VGND sg13g2_dfrbpq_1
XFILLER_13_117 VPWR VGND sg13g2_fill_2
X_6968_ _6974_/A _7187_/A _7132_/B _7132_/D VPWR VGND sg13g2_nor3_1
X_5919_ _9316_/D _5918_/Y _5935_/A2 _5912_/Y VPWR VGND sg13g2_o21ai_1
X_6899_ _6899_/X _8923_/Q _8955_/Q _6909_/S VPWR VGND sg13g2_mux2_1
X_9687_ _9687_/Q _9689_/CLK _9687_/D fanout962/X VPWR VGND sg13g2_dfrbpq_1
XFILLER_42_35 VPWR VGND sg13g2_fill_1
X_8638_ _8638_/Q _9449_/CLK _8638_/D fanout970/X VPWR VGND sg13g2_dfrbpq_1
X_8569_ _8569_/Y _8577_/A _8577_/B _8569_/C VPWR VGND sg13g2_nand3_1
XFILLER_21_194 VPWR VGND sg13g2_fill_2
Xplace2280 _6534_/A _9410_/Q VPWR VGND sg13g2_buf_1
Xplace2291 _4945_/A _4925_/A2 VPWR VGND sg13g2_buf_1
XFILLER_107_61 VPWR VGND sg13g2_decap_8
XFILLER_89_662 VPWR VGND sg13g2_fill_2
XFILLER_89_651 VPWR VGND sg13g2_decap_4
XFILLER_77_802 VPWR VGND sg13g2_fill_2
XFILLER_103_472 VPWR VGND sg13g2_decap_4
XFILLER_76_323 VPWR VGND sg13g2_fill_1
XFILLER_76_345 VPWR VGND sg13g2_fill_2
XFILLER_29_261 VPWR VGND sg13g2_decap_8
XFILLER_83_42 VPWR VGND sg13g2_fill_1
XFILLER_45_754 VPWR VGND sg13g2_decap_8
X_9515__2865 _9515_/RESET_B VPWR VGND sg13g2_tiehi
XFILLER_45_787 VPWR VGND sg13g2_decap_8
XFILLER_40_470 VPWR VGND sg13g2_decap_4
XFILLER_8_154 VPWR VGND sg13g2_decap_8
XFILLER_8_143 VPWR VGND sg13g2_decap_4
XFILLER_8_187 VPWR VGND sg13g2_decap_8
XFILLER_114_748 VPWR VGND sg13g2_decap_8
XFILLER_113_247 VPWR VGND sg13g2_decap_8
XFILLER_113_225 VPWR VGND sg13g2_fill_2
XFILLER_68_802 VPWR VGND sg13g2_fill_2
XFILLER_95_643 VPWR VGND sg13g2_decap_4
XFILLER_95_632 VPWR VGND sg13g2_fill_1
XFILLER_95_676 VPWR VGND sg13g2_decap_8
XFILLER_55_507 VPWR VGND sg13g2_decap_8
XFILLER_94_186 VPWR VGND sg13g2_fill_1
X_7940_ _7940_/Y _7950_/A _8982_/Q _8430_/C VPWR VGND sg13g2_nand3_1
XFILLER_48_570 VPWR VGND sg13g2_fill_1
X_7871_ _7871_/Y _9258_/Q _8513_/B _7871_/B1 VPWR VGND sg13g2_a21oi_1
XFILLER_82_348 VPWR VGND sg13g2_fill_1
XFILLER_36_754 VPWR VGND sg13g2_fill_1
X_9610_ _9610_/Q _9621_/CLK _9610_/D _9610_/RESET_B VPWR VGND sg13g2_dfrbpq_1
X_6822_ _9570_/D _9603_/Q _9570_/Q _6836_/S VPWR VGND sg13g2_mux2_1
XFILLER_35_264 VPWR VGND sg13g2_decap_4
XFILLER_36_776 VPWR VGND sg13g2_decap_4
XFILLER_36_798 VPWR VGND sg13g2_fill_2
XFILLER_63_595 VPWR VGND sg13g2_fill_1
XFILLER_50_201 VPWR VGND sg13g2_decap_8
XFILLER_23_415 VPWR VGND sg13g2_decap_8
XFILLER_23_437 VPWR VGND sg13g2_decap_8
X_6753_ _9512_/D _9512_/Q _9422_/Q _6783_/S VPWR VGND sg13g2_mux2_1
X_9541_ _9541_/Q _9686_/CLK _9541_/D _9541_/RESET_B VPWR VGND sg13g2_dfrbpq_1
X_6684_ _9459_/D _4346_/A _6686_/B _6683_/Y VPWR VGND sg13g2_a21oi_1
X_5704_ _8710_/D _9637_/D _5704_/B VPWR VGND sg13g2_and2_1
X_9472_ _9472_/Q clkload6/A _9472_/D _9472_/RESET_B VPWR VGND sg13g2_dfrbpq_1
X_8423_ _9215_/D _5362_/C _8432_/A _8422_/Y VPWR VGND sg13g2_o21ai_1
X_5635_ _8620_/D _5635_/A VPWR VGND sg13g2_inv_1
X_5566_ _8643_/D _5565_/Y _5564_/Y _5581_/B1 VPWR VGND sg13g2_a21oi_1
X_8354_ _9177_/D _5345_/C _8355_/A _8353_/Y VPWR VGND sg13g2_o21ai_1
X_7305_ _7306_/B _9276_/Q _7828_/A2 _7788_/B1 _8835_/Q _7304_/Y VPWR VGND sg13g2_a221oi_1
X_4517_ _5392_/D _6037_/C _4517_/B VPWR VGND sg13g2_and2_1
X_8285_ _8285_/Y _9143_/Q _8285_/B VPWR VGND sg13g2_nand2_1
X_5497_ _5497_/Y _5494_/X _5621_/B _5623_/B1 VPWR VGND sg13g2_a21oi_1
XFILLER_104_225 VPWR VGND sg13g2_fill_1
X_7236_ _7236_/Y _7236_/A _7236_/B _7236_/C _7236_/D VPWR VGND sg13g2_nand4_1
X_4448_ _6018_/B _6046_/A _6071_/B _7187_/A VPWR VGND sg13g2_nor3_1
X_9565__2825 _9565_/RESET_B VPWR VGND sg13g2_tiehi
X_4379_ _4379_/Y _8706_/Q _9641_/Q VPWR VGND sg13g2_nand2b_1
X_7167_ _8874_/D _7166_/Y _8874_/Q _7185_/S VPWR VGND sg13g2_mux2_1
X_7098_ _8852_/D _7097_/Y _8852_/Q _7110_/S VPWR VGND sg13g2_mux2_1
X_6118_ _6118_/Y _6176_/A _6117_/Y _6410_/C VPWR VGND sg13g2_a21oi_1
XFILLER_85_164 VPWR VGND sg13g2_fill_1
X_6049_ _6958_/C _6049_/A _6049_/B _6049_/C _6049_/D VPWR VGND sg13g2_nor4_1
XFILLER_27_721 VPWR VGND sg13g2_decap_8
XFILLER_73_337 VPWR VGND sg13g2_fill_2
XFILLER_37_79 VPWR VGND sg13g2_fill_2
XFILLER_54_595 VPWR VGND sg13g2_decap_8
XFILLER_53_23 VPWR VGND sg13g2_decap_4
XFILLER_14_437 VPWR VGND sg13g2_fill_1
XFILLER_41_212 VPWR VGND sg13g2_decap_4
XFILLER_42_746 VPWR VGND sg13g2_decap_8
XFILLER_41_278 VPWR VGND sg13g2_fill_1
XFILLER_6_636 VPWR VGND sg13g2_fill_2
XFILLER_118_93 VPWR VGND sg13g2_decap_8
XFILLER_123_589 VPWR VGND sg13g2_decap_8
XFILLER_123_578 VPWR VGND sg13g2_fill_1
XFILLER_123_567 VPWR VGND sg13g2_decap_8
XFILLER_110_206 VPWR VGND sg13g2_fill_2
XFILLER_78_75 VPWR VGND sg13g2_decap_4
XFILLER_78_53 VPWR VGND sg13g2_decap_4
XFILLER_110_239 VPWR VGND sg13g2_fill_1
XFILLER_92_624 VPWR VGND sg13g2_fill_1
XFILLER_49_378 VPWR VGND sg13g2_fill_1
XFILLER_37_518 VPWR VGND sg13g2_fill_1
XFILLER_80_808 VPWR VGND sg13g2_fill_1
XFILLER_18_743 VPWR VGND sg13g2_fill_1
XFILLER_60_510 VPWR VGND sg13g2_fill_2
XFILLER_32_223 VPWR VGND sg13g2_decap_8
XFILLER_33_724 VPWR VGND sg13g2_decap_4
XFILLER_32_256 VPWR VGND sg13g2_decap_4
XFILLER_60_598 VPWR VGND sg13g2_decap_8
X_5420_ _5420_/Y _9628_/Q _9706_/Q VPWR VGND sg13g2_nor2b_1
X_5351_ _8791_/D _5375_/A _5375_/B _5351_/C _5375_/D VPWR VGND sg13g2_nor4_1
X_8070_ _8070_/Y _8070_/A _8097_/B VPWR VGND sg13g2_nand2_1
X_5282_ _8774_/D _5288_/A1 _5366_/C _5281_/Y _5336_/B2 VPWR VGND sg13g2_a22oi_1
X_4302_ _7244_/A _7245_/A VPWR VGND sg13g2_inv_1
XFILLER_102_729 VPWR VGND sg13g2_decap_8
X_7021_ _8219_/B _6523_/C _7004_/Y _7029_/A VPWR VGND sg13g2_a21oi_1
XFILLER_4_83 VPWR VGND sg13g2_decap_4
XFILLER_110_751 VPWR VGND sg13g2_fill_1
X_8972_ _8972_/Q _9251_/CLK _8972_/D place2461/X VPWR VGND sg13g2_dfrbpq_1
X_7923_ _8974_/D _5359_/C _7953_/A _7922_/Y VPWR VGND sg13g2_o21ai_1
XFILLER_83_679 VPWR VGND sg13g2_fill_2
X_7854_ _8931_/D _8931_/Q _7324_/Y _7885_/S VPWR VGND sg13g2_mux2_1
XFILLER_63_370 VPWR VGND sg13g2_decap_8
XFILLER_51_532 VPWR VGND sg13g2_decap_8
X_7785_ _7785_/Y _7785_/A _7785_/B _7785_/C _7785_/D VPWR VGND sg13g2_nor4_1
X_6805_ _9555_/D _9555_/Q _6804_/D _6804_/Y VPWR VGND sg13g2_a21o_1
X_9524_ _9524_/Q _9567_/CLK _9524_/D _9524_/RESET_B VPWR VGND sg13g2_dfrbpq_1
X_6736_ _9504_/D _9545_/Q _9504_/Q _6736_/S VPWR VGND sg13g2_mux2_1
X_4997_ _4997_/Y _4997_/A _4997_/B VPWR VGND sg13g2_nor2_1
XFILLER_23_37 VPWR VGND sg13g2_fill_1
X_9455_ _9455_/Q _9649_/CLK _9455_/D fanout977/X VPWR VGND sg13g2_dfrbpq_1
X_6667_ _9451_/D _6569_/Y _6666_/Y _6664_/Y VPWR VGND sg13g2_o21ai_1
X_9619__2771 _9619_/RESET_B VPWR VGND sg13g2_tiehi
X_6598_ _6598_/Y _6661_/C _8633_/Q _9565_/Q _6669_/B2 VPWR VGND sg13g2_a22oi_1
X_5618_ _5618_/Y _5625_/B _6541_/A _8662_/Q _6541_/B VPWR VGND sg13g2_nand4_1
X_8406_ _9203_/D _5371_/C _8407_/A _8405_/Y VPWR VGND sg13g2_o21ai_1
X_9386_ _9386_/Q _9414_/CLK _9386_/D place2501/X VPWR VGND sg13g2_dfrbpq_1
X_5549_ _5549_/Y _6614_/A _5579_/B VPWR VGND sg13g2_nand2_1
X_8337_ _8337_/Y _8337_/A _8343_/B VPWR VGND sg13g2_nand2_1
XFILLER_105_545 VPWR VGND sg13g2_decap_4
XFILLER_2_127 VPWR VGND sg13g2_decap_8
XFILLER_3_7 VPWR VGND sg13g2_decap_8
XFILLER_120_504 VPWR VGND sg13g2_decap_8
XFILLER_105_567 VPWR VGND sg13g2_decap_4
X_8268_ _9134_/D _8563_/D _8074_/Y _8267_/Y VPWR VGND sg13g2_o21ai_1
XFILLER_105_589 VPWR VGND sg13g2_decap_8
X_8199_ _8199_/Y _8199_/A _8219_/B VPWR VGND sg13g2_nand2_1
X_7219_ _7219_/Y _5369_/C _7222_/A2 _7218_/Y VPWR VGND sg13g2_o21ai_1
XFILLER_48_12 VPWR VGND sg13g2_decap_8
XFILLER_86_440 VPWR VGND sg13g2_decap_8
XFILLER_19_518 VPWR VGND sg13g2_decap_8
XFILLER_100_272 VPWR VGND sg13g2_decap_4
XFILLER_104_73 VPWR VGND sg13g2_decap_8
XFILLER_64_44 VPWR VGND sg13g2_decap_8
XFILLER_27_540 VPWR VGND sg13g2_decap_8
XFILLER_73_189 VPWR VGND sg13g2_decap_4
XFILLER_15_757 VPWR VGND sg13g2_fill_1
XFILLER_15_768 VPWR VGND sg13g2_fill_2
XFILLER_30_705 VPWR VGND sg13g2_fill_2
XFILLER_9_28 VPWR VGND sg13g2_decap_8
XFILLER_42_598 VPWR VGND sg13g2_decap_4
XFILLER_10_484 VPWR VGND sg13g2_decap_8
XFILLER_123_320 VPWR VGND sg13g2_fill_1
XFILLER_108_394 VPWR VGND sg13g2_decap_8
XFILLER_89_85 VPWR VGND sg13g2_fill_1
XFILLER_123_364 VPWR VGND sg13g2_decap_8
XFILLER_123_331 VPWR VGND sg13g2_decap_8
XFILLER_97_716 VPWR VGND sg13g2_decap_8
XFILLER_96_215 VPWR VGND sg13g2_decap_4
XFILLER_1_160 VPWR VGND sg13g2_fill_2
XFILLER_2_694 VPWR VGND sg13g2_decap_4
XFILLER_49_120 VPWR VGND sg13g2_fill_1
XFILLER_92_410 VPWR VGND sg13g2_decap_4
XFILLER_92_432 VPWR VGND sg13g2_fill_1
XFILLER_37_337 VPWR VGND sg13g2_decap_8
XFILLER_92_454 VPWR VGND sg13g2_fill_1
X_4920_ _4920_/Y _9393_/Q _4934_/B _4919_/Y VPWR VGND sg13g2_a21oi_1
X_4851_ _4851_/Y _4880_/B _4846_/Y _4850_/Y VPWR VGND sg13g2_o21ai_1
XFILLER_33_543 VPWR VGND sg13g2_decap_8
XFILLER_60_362 VPWR VGND sg13g2_fill_2
XFILLER_21_716 VPWR VGND sg13g2_decap_8
XFILLER_60_395 VPWR VGND sg13g2_fill_1
X_4782_ _4782_/Y _4995_/S _4855_/A _4816_/B _4782_/D VPWR VGND sg13g2_nand4_1
X_7570_ _7570_/Y _9466_/Q _7570_/B _7570_/C _7570_/D VPWR VGND sg13g2_nor4_1
XFILLER_119_637 VPWR VGND sg13g2_decap_8
X_6521_ _6521_/Y _8540_/A _8532_/B _6521_/C VPWR VGND sg13g2_nand3_1
XFILLER_20_259 VPWR VGND sg13g2_decap_8
XFILLER_118_125 VPWR VGND sg13g2_decap_8
X_9240_ _9240_/Q _9242_/CLK _9240_/D place2495/X VPWR VGND sg13g2_dfrbpq_1
X_6452_ _6452_/Y _6510_/B _9232_/Q _6459_/C _6516_/C VPWR VGND sg13g2_nand4_1
XFILLER_118_169 VPWR VGND sg13g2_fill_1
XFILLER_118_158 VPWR VGND sg13g2_decap_8
X_9171_ _9171_/Q _9199_/CLK _9171_/D place2432/X VPWR VGND sg13g2_dfrbpq_1
X_5403_ _5404_/A _7028_/B _5403_/B _9479_/Q VPWR VGND sg13g2_nand3b_1
XFILLER_62_0 VPWR VGND sg13g2_decap_4
Xclkload30 clkload30/Y _9701_/CLK VPWR VGND sg13g2_inv_4
X_8122_ _9061_/D _8130_/A1 _7909_/Y _8121_/Y VPWR VGND sg13g2_o21ai_1
X_6383_ _6383_/Y _6079_/A _6176_/Y _6382_/Y VPWR VGND sg13g2_o21ai_1
XFILLER_88_716 VPWR VGND sg13g2_fill_2
X_5334_ _5338_/A _5334_/A _5334_/B _5334_/C _9888_/A VPWR VGND sg13g2_nand4_1
XFILLER_0_609 VPWR VGND sg13g2_fill_2
XFILLER_102_526 VPWR VGND sg13g2_decap_8
X_5265_ _5265_/Y _5272_/A _5286_/B _9878_/A VPWR VGND sg13g2_a21oi_1
X_8053_ _8053_/Y _8086_/A _9483_/Q _8095_/C _8068_/D VPWR VGND sg13g2_nand4_1
XFILLER_87_237 VPWR VGND sg13g2_decap_4
X_7004_ _7004_/Y _7004_/A _7028_/B _7004_/C _7028_/A VPWR VGND sg13g2_nor4_1
X_5196_ _8760_/D _5274_/A1 _5352_/C _5195_/Y _5269_/A1 VPWR VGND sg13g2_a22oi_1
X_9474__2906 _9474_/RESET_B VPWR VGND sg13g2_tiehi
XFILLER_96_782 VPWR VGND sg13g2_fill_2
XFILLER_96_771 VPWR VGND sg13g2_decap_8
XFILLER_68_451 VPWR VGND sg13g2_decap_8
X_9510__2870 _9510_/RESET_B VPWR VGND sg13g2_tiehi
XFILLER_83_432 VPWR VGND sg13g2_decap_8
X_8955_ _8955_/Q _9304_/CLK _8955_/D place2414/X VPWR VGND sg13g2_dfrbpq_1
X_7906_ _7906_/Y _7924_/A _8967_/Q _8383_/C VPWR VGND sg13g2_nand3_1
X_8886_ _8886_/Q _9253_/CLK _8886_/D place2479/X VPWR VGND sg13g2_dfrbpq_1
XFILLER_51_340 VPWR VGND sg13g2_decap_8
X_7837_ _7841_/B _7839_/C _7839_/B _8989_/Q VPWR VGND sg13g2_nor3_1
XFILLER_12_727 VPWR VGND sg13g2_fill_2
X_7768_ _7768_/Y _7768_/A _7768_/B _7768_/C _7768_/D VPWR VGND sg13g2_nor4_1
X_6719_ _9487_/D _9528_/Q _9487_/Q _6729_/S VPWR VGND sg13g2_mux2_1
X_7699_ _7714_/D _9297_/Q _7796_/A2 _7796_/B1 _9329_/Q VPWR VGND sg13g2_a22oi_1
Xclkload2 clkload2/X clkload2/A VPWR VGND sg13g2_buf_16
X_9507_ _9507_/Q _9511_/CLK _9507_/D _9507_/RESET_B VPWR VGND sg13g2_dfrbpq_1
X_9438_ _9438_/Q _9567_/CLK _9438_/D fanout982/X VPWR VGND sg13g2_dfrbpq_1
XFILLER_20_782 VPWR VGND sg13g2_decap_4
XFILLER_50_68 VPWR VGND sg13g2_fill_1
XFILLER_105_320 VPWR VGND sg13g2_fill_2
X_9369_ _9369_/Q clkload9/A _9369_/D place2490/X VPWR VGND sg13g2_dfrbpq_1
XFILLER_117_191 VPWR VGND sg13g2_decap_8
XFILLER_59_11 VPWR VGND sg13g2_fill_2
XFILLER_105_386 VPWR VGND sg13g2_decap_8
XFILLER_78_237 VPWR VGND sg13g2_fill_1
XFILLER_59_451 VPWR VGND sg13g2_fill_1
XFILLER_19_337 VPWR VGND sg13g2_fill_1
XFILLER_46_123 VPWR VGND sg13g2_decap_4
XFILLER_75_98 VPWR VGND sg13g2_fill_2
XFILLER_75_87 VPWR VGND sg13g2_decap_8
XFILLER_46_156 VPWR VGND sg13g2_fill_1
XFILLER_61_104 VPWR VGND sg13g2_decap_8
XFILLER_42_340 VPWR VGND sg13g2_fill_1
XFILLER_15_576 VPWR VGND sg13g2_fill_2
XFILLER_15_587 VPWR VGND sg13g2_decap_8
XFILLER_30_502 VPWR VGND sg13g2_decap_8
X_9560__2830 _9560_/RESET_B VPWR VGND sg13g2_tiehi
Xplace2109 _8086_/D _8068_/D VPWR VGND sg13g2_buf_1
XFILLER_116_629 VPWR VGND sg13g2_decap_8
XFILLER_10_292 VPWR VGND sg13g2_fill_1
XFILLER_10_281 VPWR VGND sg13g2_decap_8
XFILLER_6_263 VPWR VGND sg13g2_fill_2
XFILLER_108_191 VPWR VGND sg13g2_decap_8
XFILLER_123_161 VPWR VGND sg13g2_decap_8
XFILLER_123_194 VPWR VGND sg13g2_decap_8
XFILLER_97_568 VPWR VGND sg13g2_fill_2
X_5050_ _5050_/Y _5055_/A _8753_/Q _5110_/A VPWR VGND sg13g2_nand3b_1
X_9593__2797 _9593_/RESET_B VPWR VGND sg13g2_tiehi
XFILLER_111_389 VPWR VGND sg13g2_decap_4
XFILLER_97_579 VPWR VGND sg13g2_fill_1
XFILLER_38_613 VPWR VGND sg13g2_fill_2
XFILLER_38_635 VPWR VGND sg13g2_fill_1
XFILLER_53_605 VPWR VGND sg13g2_decap_8
X_5952_ _5952_/Y _5952_/A _5952_/B VPWR VGND sg13g2_nand2_1
XFILLER_92_262 VPWR VGND sg13g2_decap_8
X_8740_ _8740_/Q _9675_/CLK _8740_/D place2450/X VPWR VGND sg13g2_dfrbpq_1
XFILLER_80_424 VPWR VGND sg13g2_decap_4
XFILLER_25_329 VPWR VGND sg13g2_decap_8
X_4903_ _4903_/Y _4903_/A _4903_/B _4903_/C _4903_/D VPWR VGND sg13g2_nand4_1
X_5883_ _5883_/Y _5891_/A1 _5930_/A2 _5883_/B1 _5891_/B2 VPWR VGND sg13g2_a22oi_1
XFILLER_61_682 VPWR VGND sg13g2_decap_8
X_8671_ _8671_/Q _8678_/CLK _8671_/D fanout945/X VPWR VGND sg13g2_dfrbpq_1
XFILLER_33_340 VPWR VGND sg13g2_decap_8
X_7622_ _7625_/A _7759_/A _7799_/B _9102_/Q VPWR VGND sg13g2_nor3_1
XFILLER_21_535 VPWR VGND sg13g2_decap_8
X_4834_ _4834_/Y _4789_/Y _4834_/B _4995_/S VPWR VGND sg13g2_nand3b_1
X_7553_ _7553_/Y _7553_/A _7553_/B _7553_/C _7553_/D VPWR VGND sg13g2_nand4_1
X_4765_ _4765_/Y _4782_/D _4903_/D VPWR VGND sg13g2_nor2_1
X_6504_ _6504_/Y _6504_/A1 _6312_/A _6504_/B1 VPWR VGND sg13g2_a21oi_1
XFILLER_119_456 VPWR VGND sg13g2_decap_4
X_9528__2852 _9528_/RESET_B VPWR VGND sg13g2_tiehi
X_4696_ _4702_/A _9670_/Q _8739_/Q _9673_/Q VPWR VGND sg13g2_a21oi_1
X_7484_ _7484_/Y _7484_/A _7484_/B _7484_/C VPWR VGND sg13g2_nand3_1
X_9223_ _9223_/Q clkload7/A _9223_/D place2461/X VPWR VGND sg13g2_dfrbpq_1
XFILLER_106_139 VPWR VGND sg13g2_decap_8
Xplace1920 _8513_/B _8515_/A VPWR VGND sg13g2_buf_1
X_6435_ _6435_/Y _6504_/A1 _6463_/A2 _6435_/B1 VPWR VGND sg13g2_a21oi_1
XFILLER_20_38 VPWR VGND sg13g2_fill_2
Xplace1942 _7680_/B1 _6972_/Y VPWR VGND sg13g2_buf_1
Xplace1964 _7237_/B2 _6962_/D VPWR VGND sg13g2_buf_1
Xplace1931 _6346_/B _6379_/A2 VPWR VGND sg13g2_buf_1
Xplace1953 _6130_/B _6048_/Y VPWR VGND sg13g2_buf_1
X_6366_ _6366_/Y _4429_/Y _9247_/Q _6365_/Y VPWR VGND sg13g2_a21oi_1
X_9154_ _9154_/Q _9188_/CLK _9154_/D place2474/X VPWR VGND sg13g2_dfrbpq_1
X_5317_ _5317_/Y _5317_/A _5317_/B VPWR VGND sg13g2_nand2_1
Xplace1986 _7640_/A2 _5383_/Y VPWR VGND sg13g2_buf_1
Xplace1997 _5360_/B _5373_/B VPWR VGND sg13g2_buf_1
X_9085_ _9085_/Q _9188_/CLK _9085_/D place2484/X VPWR VGND sg13g2_dfrbpq_1
X_8105_ _8105_/Y _9053_/Q _8129_/B VPWR VGND sg13g2_nand2_1
XFILLER_0_417 VPWR VGND sg13g2_decap_8
Xplace1975 _8244_/A1 _8286_/A1 VPWR VGND sg13g2_buf_1
XFILLER_88_568 VPWR VGND sg13g2_fill_2
XFILLER_88_557 VPWR VGND sg13g2_decap_8
X_8036_ _8036_/Y _8036_/A _8099_/B VPWR VGND sg13g2_nand2_1
X_6297_ _9370_/D _6297_/A VPWR VGND sg13g2_inv_1
X_5248_ _5254_/B _9874_/A _9875_/A _5280_/A _5280_/B VPWR VGND sg13g2_nand4_1
XFILLER_69_771 VPWR VGND sg13g2_fill_1
X_5179_ _5179_/X _5192_/C _5188_/B VPWR VGND sg13g2_and2_1
XFILLER_29_635 VPWR VGND sg13g2_decap_8
XFILLER_28_134 VPWR VGND sg13g2_decap_8
X_8938_ _8938_/Q _9504_/CLK _8938_/D place2429/X VPWR VGND sg13g2_dfrbpq_1
XFILLER_56_476 VPWR VGND sg13g2_decap_8
XFILLER_71_446 VPWR VGND sg13g2_decap_8
XFILLER_71_435 VPWR VGND sg13g2_decap_4
XFILLER_45_68 VPWR VGND sg13g2_decap_8
X_8869_ _8869_/Q _9692_/CLK _8869_/D place2506/X VPWR VGND sg13g2_dfrbpq_1
XFILLER_12_546 VPWR VGND sg13g2_fill_2
Xinput2543 _7481_/B2 hartinfo_i[12] VPWR VGND sg13g2_buf_1
Xinput2576 _6520_/A1 master_gnt_i VPWR VGND sg13g2_buf_1
Xclkbuf_3_6__f_clk_i clkbuf_3_6__f_clk_i/X clkbuf_0_clk_i/X VPWR VGND sg13g2_buf_8
Xinput2554 _7695_/B2 hartinfo_i[22] VPWR VGND sg13g2_buf_1
Xinput2565 _7321_/B2 hartinfo_i[3] VPWR VGND sg13g2_buf_1
Xinput2598 _5995_/A master_rdata_i[28] VPWR VGND sg13g2_buf_1
Xinput2587 _5915_/A1 master_rdata_i[18] VPWR VGND sg13g2_buf_1
XFILLER_4_701 VPWR VGND sg13g2_decap_4
XFILLER_106_640 VPWR VGND sg13g2_decap_8
XFILLER_3_244 VPWR VGND sg13g2_decap_8
XFILLER_105_161 VPWR VGND sg13g2_decap_8
XFILLER_105_172 VPWR VGND sg13g2_fill_2
XFILLER_75_752 VPWR VGND sg13g2_decap_4
X_9578__2812 _9578_/RESET_B VPWR VGND sg13g2_tiehi
XFILLER_74_262 VPWR VGND sg13g2_fill_1
XFILLER_47_498 VPWR VGND sg13g2_fill_1
XFILLER_90_755 VPWR VGND sg13g2_decap_8
XFILLER_35_90 VPWR VGND sg13g2_fill_2
XFILLER_42_181 VPWR VGND sg13g2_decap_8
XFILLER_30_387 VPWR VGND sg13g2_decap_8
X_4550_ _4550_/Y _7644_/A _7644_/B VPWR VGND sg13g2_nand2b_1
X_4481_ _4482_/B _4481_/A _4481_/B _4481_/C VPWR VGND sg13g2_and3_1
XFILLER_98_800 VPWR VGND sg13g2_fill_1
X_6220_ _6220_/Y _8852_/Q _7229_/B2 _6219_/X _6434_/A2 VPWR VGND sg13g2_a22oi_1
X_6151_ _6151_/Y _9154_/Q _6173_/A _6077_/A _9030_/Q VPWR VGND sg13g2_a22oi_1
XFILLER_112_654 VPWR VGND sg13g2_decap_8
X_5102_ _5119_/B _5084_/A _5084_/B _5100_/B _5132_/D _5089_/Y VPWR VGND sg13g2_a221oi_1
X_6082_ _6082_/Y _8835_/Q _6375_/A2 _6129_/A _6081_/X _6080_/Y VPWR VGND sg13g2_a221oi_1
XFILLER_25_0 VPWR VGND sg13g2_decap_8
XFILLER_111_197 VPWR VGND sg13g2_fill_2
X_5033_ _6534_/D _8540_/A _8532_/B VPWR VGND sg13g2_nand2_1
XFILLER_38_465 VPWR VGND sg13g2_fill_1
XFILLER_93_560 VPWR VGND sg13g2_fill_1
XFILLER_66_796 VPWR VGND sg13g2_fill_2
XFILLER_38_487 VPWR VGND sg13g2_fill_1
X_6984_ _6987_/C _8831_/Q _7719_/B VPWR VGND sg13g2_nor2_1
XFILLER_53_446 VPWR VGND sg13g2_fill_2
XFILLER_19_690 VPWR VGND sg13g2_fill_1
X_5935_ _9318_/D _5934_/Y _5935_/A2 _5928_/Y VPWR VGND sg13g2_o21ai_1
X_8723_ _8723_/Q _9678_/CLK _9622_/Q fanout966/X VPWR VGND sg13g2_dfrbpq_1
X_5866_ _5866_/Y _5890_/A _5890_/B _5929_/A _5890_/D VPWR VGND sg13g2_nand4_1
X_8654_ _8654_/Q _9645_/CLK _8654_/D fanout969/X VPWR VGND sg13g2_dfrbpq_1
X_7605_ _7606_/D _7718_/A _9132_/Q _7723_/C VPWR VGND sg13g2_nor3_1
X_4817_ _4817_/Y _9381_/Q _4891_/A2 _4959_/A _4816_/X VPWR VGND sg13g2_a22oi_1
X_5797_ _9291_/D _5797_/A VPWR VGND sg13g2_inv_1
X_8585_ _8586_/A _9285_/Q _8585_/A2 _8585_/B1 _9482_/Q VPWR VGND sg13g2_a22oi_1
XFILLER_119_264 VPWR VGND sg13g2_fill_1
X_7536_ _7536_/Y _7829_/A _7536_/B VPWR VGND sg13g2_nor2_1
X_4748_ _4750_/B _4903_/B _4903_/C VPWR VGND sg13g2_nand2_1
XFILLER_31_59 VPWR VGND sg13g2_decap_4
X_4679_ _9662_/D _6954_/S _4682_/A _4678_/Y VPWR VGND sg13g2_o21ai_1
XFILLER_107_415 VPWR VGND sg13g2_fill_2
Xplace2440 place2440/X place2451/X VPWR VGND sg13g2_buf_1
X_7467_ _7467_/Y _9063_/Q _7819_/B _7469_/A VPWR VGND sg13g2_nand3b_1
XFILLER_103_7 VPWR VGND sg13g2_fill_2
Xplace2451 place2451/X place2452/X VPWR VGND sg13g2_buf_1
X_6418_ _6418_/Y _6417_/X _6434_/A2 _8879_/Q _6441_/A2 VPWR VGND sg13g2_a22oi_1
Xplace2473 place2473/X place2476/X VPWR VGND sg13g2_buf_1
X_9206_ _9206_/Q clkload7/A _9206_/D place2464/X VPWR VGND sg13g2_dfrbpq_1
Xplace2462 place2462/X place2463/X VPWR VGND sg13g2_buf_1
Xplace1772 _6653_/A1 _6656_/A1 VPWR VGND sg13g2_buf_1
X_7398_ _7398_/Y _7398_/A _7576_/S VPWR VGND sg13g2_nor2_1
X_9137_ _9137_/Q _9199_/CLK _9137_/D place2424/X VPWR VGND sg13g2_dfrbpq_1
Xplace2484 place2484/X place2485/X VPWR VGND sg13g2_buf_1
Xplace2495 place2495/X place2506/X VPWR VGND sg13g2_buf_1
XFILLER_103_632 VPWR VGND sg13g2_fill_1
XFILLER_102_120 VPWR VGND sg13g2_decap_8
Xplace1794 _5215_/A _5272_/A VPWR VGND sg13g2_buf_1
Xhold3120 _8329_/A _9165_/Q VPWR VGND sg13g2_dlygate4sd3_1
X_6349_ _6349_/X _8992_/Q _9054_/Q _9116_/Q _9178_/Q _6061_/A _6349_/S1 VPWR VGND
+ sg13g2_mux4_1
Xplace1783 _8349_/B _8299_/B VPWR VGND sg13g2_buf_1
Xhold3131 _5673_/B2 _8590_/Q VPWR VGND sg13g2_dlygate4sd3_1
Xhold3142 _8468_/B _9239_/Q VPWR VGND sg13g2_dlygate4sd3_1
Xhold3164 _8263_/A _9132_/Q VPWR VGND sg13g2_dlygate4sd3_1
Xhold3153 _8225_/A _9113_/Q VPWR VGND sg13g2_dlygate4sd3_1
Xhold3175 _8169_/A _9085_/Q VPWR VGND sg13g2_dlygate4sd3_1
X_9068_ _9068_/Q _9501_/CLK _9068_/D place2470/X VPWR VGND sg13g2_dfrbpq_1
Xhold3186 _4685_/A _8719_/Q VPWR VGND sg13g2_dlygate4sd3_1
Xhold3197 _8046_/A _9031_/Q VPWR VGND sg13g2_dlygate4sd3_1
X_8019_ _8019_/Y _8019_/A _9020_/Q _8411_/C VPWR VGND sg13g2_nand3_1
XFILLER_84_582 VPWR VGND sg13g2_decap_8
XFILLER_29_498 VPWR VGND sg13g2_decap_4
XFILLER_84_593 VPWR VGND sg13g2_fill_2
XFILLER_71_265 VPWR VGND sg13g2_fill_1
XFILLER_25_660 VPWR VGND sg13g2_decap_8
XFILLER_9_804 VPWR VGND sg13g2_fill_1
XFILLER_8_369 VPWR VGND sg13g2_decap_8
XFILLER_21_70 VPWR VGND sg13g2_fill_1
XFILLER_106_470 VPWR VGND sg13g2_decap_8
XFILLER_98_118 VPWR VGND sg13g2_decap_8
XFILLER_4_564 VPWR VGND sg13g2_decap_8
XFILLER_97_63 VPWR VGND sg13g2_fill_2
XFILLER_4_597 VPWR VGND sg13g2_decap_8
XFILLER_79_376 VPWR VGND sg13g2_decap_8
XFILLER_67_527 VPWR VGND sg13g2_decap_8
XFILLER_35_402 VPWR VGND sg13g2_decap_4
XFILLER_47_251 VPWR VGND sg13g2_fill_2
XFILLER_90_541 VPWR VGND sg13g2_fill_2
XFILLER_90_530 VPWR VGND sg13g2_decap_8
XFILLER_63_755 VPWR VGND sg13g2_decap_8
XFILLER_62_221 VPWR VGND sg13g2_decap_8
XFILLER_90_563 VPWR VGND sg13g2_fill_2
XFILLER_63_766 VPWR VGND sg13g2_fill_2
X_5720_ _5720_/Y _5735_/A _5735_/B _9307_/Q _5735_/D VPWR VGND sg13g2_nand4_1
XFILLER_62_298 VPWR VGND sg13g2_decap_8
X_5651_ _5652_/A _8610_/Q _5699_/A2 _5699_/B1 _5651_/B2 VPWR VGND sg13g2_a22oi_1
X_5582_ _5582_/Y _5585_/A _5585_/B _8650_/Q _5585_/D VPWR VGND sg13g2_nand4_1
X_4602_ _4694_/A _9665_/Q _4602_/B VPWR VGND sg13g2_nor2_1
X_8370_ _9185_/D _5353_/C _8375_/A _8369_/Y VPWR VGND sg13g2_o21ai_1
XFILLER_117_746 VPWR VGND sg13g2_fill_1
X_7321_ _7322_/B _9861_/A _7825_/A2 _7809_/B1 _7321_/B2 VPWR VGND sg13g2_a22oi_1
X_4533_ _7032_/C _7245_/B _9467_/Q VPWR VGND sg13g2_nor2_1
X_7252_ _7253_/D _9021_/Q _7291_/B _7249_/Y VPWR VGND sg13g2_o21ai_1
XFILLER_116_278 VPWR VGND sg13g2_decap_8
XFILLER_104_418 VPWR VGND sg13g2_fill_1
X_6203_ _6203_/Y _6202_/X _6515_/B1 _8848_/Q _6441_/A2 VPWR VGND sg13g2_a22oi_1
X_4464_ _6956_/S _8734_/Q _9680_/Q VPWR VGND sg13g2_nand2b_1
X_7183_ _7183_/Y _7831_/A _9486_/Q _7229_/B1 _7229_/B2 VPWR VGND sg13g2_a22oi_1
X_4395_ _4395_/Y _8674_/Q _5434_/B VPWR VGND sg13g2_nor2_1
XFILLER_58_516 VPWR VGND sg13g2_fill_2
X_6134_ _6136_/C _6224_/A _9230_/Q _6247_/C _6369_/D VPWR VGND sg13g2_nand4_1
XFILLER_112_484 VPWR VGND sg13g2_decap_8
XFILLER_98_696 VPWR VGND sg13g2_decap_4
XFILLER_97_173 VPWR VGND sg13g2_fill_2
XFILLER_85_335 VPWR VGND sg13g2_decap_8
XFILLER_85_302 VPWR VGND sg13g2_decap_8
X_6065_ _6065_/Y _6065_/A _6071_/D VPWR VGND sg13g2_nor2_1
X_5016_ _5016_/Y _4995_/S _4774_/Y _4888_/Y VPWR VGND sg13g2_a21oi_1
XFILLER_54_711 VPWR VGND sg13g2_fill_1
XFILLER_54_700 VPWR VGND sg13g2_decap_8
XFILLER_26_413 VPWR VGND sg13g2_decap_8
XFILLER_38_240 VPWR VGND sg13g2_decap_4
XFILLER_66_593 VPWR VGND sg13g2_fill_1
XFILLER_53_221 VPWR VGND sg13g2_decap_8
X_6967_ _6967_/Y _7820_/C _7132_/D VPWR VGND sg13g2_nand2_1
X_5918_ _5918_/Y _5934_/A1 _9481_/Q _5917_/Y VPWR VGND sg13g2_o21ai_1
X_8706_ _8706_/Q _9649_/CLK _8706_/D fanout975/X VPWR VGND sg13g2_dfrbpq_1
XFILLER_41_449 VPWR VGND sg13g2_decap_8
X_6898_ _9615_/D _6897_/X _9615_/Q _6910_/S VPWR VGND sg13g2_mux2_1
X_9686_ _9686_/Q _9686_/CLK _9686_/D fanout964/X VPWR VGND sg13g2_dfrbpq_1
XFILLER_42_14 VPWR VGND sg13g2_decap_8
X_5849_ _5849_/X _5989_/A _5915_/A1 _5889_/S VPWR VGND sg13g2_mux2_1
X_8637_ _8637_/Q _9449_/CLK _8637_/D fanout970/X VPWR VGND sg13g2_dfrbpq_1
XFILLER_108_702 VPWR VGND sg13g2_fill_2
X_8568_ _9276_/D _5848_/Y _8563_/X _8567_/Y VPWR VGND sg13g2_o21ai_1
XFILLER_108_713 VPWR VGND sg13g2_fill_1
X_7519_ _7519_/X _7775_/A _9320_/Q _7519_/C _7519_/D VPWR VGND sg13g2_and4_1
XFILLER_5_317 VPWR VGND sg13g2_fill_2
X_8499_ _9254_/D _4293_/Y _8498_/Y _9253_/Q VPWR VGND sg13g2_a21oi_1
Xplace2281 _5070_/C _9409_/Q VPWR VGND sg13g2_buf_1
Xplace2270 _7783_/B _7608_/B VPWR VGND sg13g2_buf_1
XFILLER_122_237 VPWR VGND sg13g2_fill_2
Xplace2292 _4925_/A2 _9341_/Q VPWR VGND sg13g2_buf_1
XFILLER_107_51 VPWR VGND sg13g2_decap_4
XFILLER_103_451 VPWR VGND sg13g2_decap_8
XFILLER_103_440 VPWR VGND sg13g2_fill_1
XFILLER_49_516 VPWR VGND sg13g2_fill_2
XFILLER_57_571 VPWR VGND sg13g2_fill_2
XFILLER_17_424 VPWR VGND sg13g2_decap_8
XFILLER_17_435 VPWR VGND sg13g2_fill_2
XFILLER_29_295 VPWR VGND sg13g2_fill_1
XFILLER_44_210 VPWR VGND sg13g2_decap_4
XFILLER_83_54 VPWR VGND sg13g2_decap_8
XFILLER_44_243 VPWR VGND sg13g2_decap_4
XFILLER_9_601 VPWR VGND sg13g2_decap_8
XFILLER_8_122 VPWR VGND sg13g2_decap_8
XFILLER_114_727 VPWR VGND sg13g2_fill_2
XFILLER_113_215 VPWR VGND sg13g2_fill_1
XFILLER_122_760 VPWR VGND sg13g2_decap_8
XFILLER_121_292 VPWR VGND sg13g2_fill_1
XFILLER_95_666 VPWR VGND sg13g2_fill_1
XFILLER_67_357 VPWR VGND sg13g2_fill_2
XFILLER_82_327 VPWR VGND sg13g2_decap_8
X_7870_ _8944_/D _8944_/Q _7575_/Y _7884_/S VPWR VGND sg13g2_mux2_1
XFILLER_36_733 VPWR VGND sg13g2_decap_8
X_6821_ _9569_/D _9602_/Q _9569_/Q _6836_/S VPWR VGND sg13g2_mux2_1
XFILLER_63_574 VPWR VGND sg13g2_fill_2
X_9540_ _9540_/Q _9567_/CLK _9540_/D _9540_/RESET_B VPWR VGND sg13g2_dfrbpq_1
XFILLER_35_287 VPWR VGND sg13g2_decap_4
XFILLER_92_0 VPWR VGND sg13g2_decap_8
X_6752_ _9511_/D _9511_/Q _9421_/Q _6756_/S VPWR VGND sg13g2_mux2_1
X_6683_ _6683_/Y _9459_/Q _6686_/B VPWR VGND sg13g2_nor2_1
X_5703_ _5704_/B _9637_/Q _9638_/Q VPWR VGND sg13g2_or2_1
X_9471_ _9471_/Q clkload6/A _9471_/D _9471_/RESET_B VPWR VGND sg13g2_dfrbpq_1
X_8422_ _8422_/Y _8432_/A _8422_/B _8430_/C VPWR VGND sg13g2_nand3_1
X_5634_ _5635_/A _5634_/A1 _5699_/A2 _5699_/B1 _5634_/B2 VPWR VGND sg13g2_a22oi_1
X_8353_ _8353_/Y _8355_/A _9177_/Q _8353_/C VPWR VGND sg13g2_nand3_1
X_5565_ _5565_/Y _9441_/Q _5570_/B _5580_/B1 _8643_/Q VPWR VGND sg13g2_a22oi_1
XFILLER_117_521 VPWR VGND sg13g2_fill_1
X_7304_ _7304_/Y _7304_/A _7304_/B _7304_/C _7304_/D VPWR VGND sg13g2_nand4_1
XFILLER_117_576 VPWR VGND sg13g2_decap_4
X_8284_ _9142_/D _8284_/A1 _7951_/Y _8283_/Y VPWR VGND sg13g2_o21ai_1
X_4516_ _4516_/Y _4512_/B _8494_/A _8819_/Q VPWR VGND sg13g2_o21ai_1
X_5496_ _5621_/B _9695_/Q _5496_/B VPWR VGND sg13g2_nor2_1
X_4447_ _6015_/B _4447_/A _4447_/B _4447_/C _4447_/D VPWR VGND sg13g2_nor4_1
X_7235_ _8893_/D _7234_/Y _8893_/Q _7239_/S VPWR VGND sg13g2_mux2_1
X_7166_ _7166_/Y _5354_/C _6978_/Y _7165_/Y VPWR VGND sg13g2_o21ai_1
XFILLER_113_771 VPWR VGND sg13g2_decap_8
XFILLER_112_270 VPWR VGND sg13g2_fill_1
X_4378_ _6678_/B _9639_/Q _4378_/B VPWR VGND sg13g2_nor2_1
XFILLER_98_460 VPWR VGND sg13g2_fill_1
X_6117_ _6117_/Y _6113_/Y _6117_/B VPWR VGND sg13g2_nand2b_1
X_7097_ _7097_/Y _8487_/A2 _7127_/A2 _7096_/Y VPWR VGND sg13g2_o21ai_1
XFILLER_73_316 VPWR VGND sg13g2_decap_8
X_6048_ _6048_/Y _6049_/A _6049_/B _6049_/C _6049_/D VPWR VGND sg13g2_nor4_1
XFILLER_100_498 VPWR VGND sg13g2_decap_4
XFILLER_26_221 VPWR VGND sg13g2_fill_2
XFILLER_27_744 VPWR VGND sg13g2_fill_1
XFILLER_26_243 VPWR VGND sg13g2_fill_2
XFILLER_26_298 VPWR VGND sg13g2_decap_8
X_7999_ _7999_/Y _8009_/A _9010_/Q _8391_/C VPWR VGND sg13g2_nand3_1
XFILLER_53_79 VPWR VGND sg13g2_fill_2
X_9669_ _9669_/Q _9675_/CLK _9669_/D place2443/X VPWR VGND sg13g2_dfrbpq_1
XFILLER_108_576 VPWR VGND sg13g2_decap_8
XFILLER_123_546 VPWR VGND sg13g2_decap_8
XFILLER_118_83 VPWR VGND sg13g2_decap_4
XFILLER_78_32 VPWR VGND sg13g2_decap_8
XFILLER_104_782 VPWR VGND sg13g2_decap_4
XFILLER_77_611 VPWR VGND sg13g2_fill_1
XFILLER_76_121 VPWR VGND sg13g2_fill_2
XFILLER_76_110 VPWR VGND sg13g2_decap_8
XFILLER_92_603 VPWR VGND sg13g2_decap_8
XFILLER_77_699 VPWR VGND sg13g2_fill_1
XFILLER_49_368 VPWR VGND sg13g2_fill_1
XFILLER_92_636 VPWR VGND sg13g2_decap_8
XFILLER_64_349 VPWR VGND sg13g2_decap_8
XFILLER_92_669 VPWR VGND sg13g2_fill_1
XFILLER_45_563 VPWR VGND sg13g2_fill_1
XFILLER_33_736 VPWR VGND sg13g2_decap_4
XFILLER_60_577 VPWR VGND sg13g2_fill_2
XFILLER_118_307 VPWR VGND sg13g2_fill_2
XFILLER_9_464 VPWR VGND sg13g2_fill_2
X_5350_ _8790_/D _5360_/A _5360_/B _5350_/C _5360_/D VPWR VGND sg13g2_nor4_1
X_4301_ _4513_/C _9503_/Q VPWR VGND sg13g2_inv_1
X_5281_ _5281_/Y _5281_/A _5281_/B VPWR VGND sg13g2_nand2_1
XFILLER_99_257 VPWR VGND sg13g2_fill_2
XFILLER_87_408 VPWR VGND sg13g2_decap_4
X_7020_ _8828_/D _7008_/Y _8156_/A1 _7019_/Y VPWR VGND sg13g2_o21ai_1
XFILLER_4_180 VPWR VGND sg13g2_fill_1
XFILLER_4_73 VPWR VGND sg13g2_decap_4
XFILLER_114_19 VPWR VGND sg13g2_fill_1
XFILLER_95_441 VPWR VGND sg13g2_fill_2
XFILLER_82_102 VPWR VGND sg13g2_fill_2
XFILLER_67_154 VPWR VGND sg13g2_fill_2
XFILLER_67_143 VPWR VGND sg13g2_decap_8
X_8971_ _8971_/Q clkload4/A _8971_/D place2481/X VPWR VGND sg13g2_dfrbpq_1
XFILLER_28_519 VPWR VGND sg13g2_decap_4
XFILLER_83_636 VPWR VGND sg13g2_decap_8
XFILLER_55_349 VPWR VGND sg13g2_decap_4
X_7922_ _7922_/Y _7934_/A _8974_/Q _8407_/C VPWR VGND sg13g2_nand3_1
XFILLER_36_563 VPWR VGND sg13g2_fill_2
X_7853_ _8930_/D _8930_/Q _7306_/Y _7885_/S VPWR VGND sg13g2_mux2_1
XFILLER_63_382 VPWR VGND sg13g2_decap_4
XFILLER_24_725 VPWR VGND sg13g2_decap_8
X_6804_ _6804_/Y _9555_/Q _6804_/B _6804_/C _6804_/D VPWR VGND sg13g2_nor4_1
X_7784_ _7785_/D _9017_/Q _4550_/Y _7783_/Y VPWR VGND sg13g2_o21ai_1
XFILLER_23_224 VPWR VGND sg13g2_fill_2
X_4996_ _4997_/B _4813_/A _4903_/D _5010_/B _4810_/Y _4772_/A VPWR VGND sg13g2_a221oi_1
X_9523_ _9523_/Q _9588_/CLK _9523_/D _9523_/RESET_B VPWR VGND sg13g2_dfrbpq_1
X_6735_ _9503_/D _9544_/Q _9503_/Q _6736_/S VPWR VGND sg13g2_mux2_1
X_9454_ _9454_/Q _9689_/CLK _9454_/D fanout959/X VPWR VGND sg13g2_dfrbpq_1
X_6666_ _6666_/Y _8653_/Q _6666_/A2 _6665_/X VPWR VGND sg13g2_o21ai_1
X_6597_ _6597_/Y _6597_/A _6660_/B VPWR VGND sg13g2_nand2_1
X_5617_ _8660_/D _5616_/Y _5615_/Y _5623_/B1 VPWR VGND sg13g2_a21oi_1
X_8405_ _8405_/Y _8407_/A _9203_/Q _8407_/C VPWR VGND sg13g2_nand3_1
X_9385_ _9385_/Q clkload9/A _9385_/D place2505/X VPWR VGND sg13g2_dfrbpq_1
X_5548_ _8637_/D _5547_/Y _5546_/Y _5593_/B1 VPWR VGND sg13g2_a21oi_1
X_8336_ _9168_/D _8346_/A1 _8083_/Y _8335_/Y VPWR VGND sg13g2_o21ai_1
X_8267_ _8267_/Y _8267_/A _8279_/B VPWR VGND sg13g2_nand2_1
XFILLER_105_579 VPWR VGND sg13g2_decap_4
X_5479_ _5479_/Y _9634_/Q _6945_/A VPWR VGND sg13g2_nand2_1
X_7218_ _7218_/Y _7218_/A _7218_/B _7221_/C _7221_/D VPWR VGND sg13g2_nand4_1
X_8198_ _9099_/D _8198_/A1 _7925_/Y _8197_/Y VPWR VGND sg13g2_o21ai_1
XFILLER_47_806 VPWR VGND sg13g2_fill_2
X_7149_ _7149_/Y _8034_/D _6977_/Y _7132_/Y _4435_/A VPWR VGND sg13g2_a22oi_1
XFILLER_104_30 VPWR VGND sg13g2_decap_8
XFILLER_86_463 VPWR VGND sg13g2_fill_1
XFILLER_73_102 VPWR VGND sg13g2_fill_1
XFILLER_58_198 VPWR VGND sg13g2_decap_8
XFILLER_46_349 VPWR VGND sg13g2_decap_8
XFILLER_82_691 VPWR VGND sg13g2_decap_8
XFILLER_64_67 VPWR VGND sg13g2_fill_1
XFILLER_42_500 VPWR VGND sg13g2_decap_8
XFILLER_81_190 VPWR VGND sg13g2_decap_8
XFILLER_14_268 VPWR VGND sg13g2_fill_2
XFILLER_14_279 VPWR VGND sg13g2_fill_1
XFILLER_23_791 VPWR VGND sg13g2_fill_1
XFILLER_80_99 VPWR VGND sg13g2_fill_1
XFILLER_80_77 VPWR VGND sg13g2_decap_8
XFILLER_108_340 VPWR VGND sg13g2_decap_8
XFILLER_89_42 VPWR VGND sg13g2_decap_8
XFILLER_123_343 VPWR VGND sg13g2_decap_8
XFILLER_97_739 VPWR VGND sg13g2_fill_1
XFILLER_49_110 VPWR VGND sg13g2_decap_4
XFILLER_77_452 VPWR VGND sg13g2_fill_1
XFILLER_49_176 VPWR VGND sg13g2_decap_8
XFILLER_92_499 VPWR VGND sg13g2_fill_2
XFILLER_45_371 VPWR VGND sg13g2_decap_4
X_4850_ _4850_/Y _9384_/Q _4891_/A2 _4849_/Y _4853_/A VPWR VGND sg13g2_a22oi_1
X_6520_ _6521_/C _6520_/A1 _5039_/Y _6519_/X VPWR VGND sg13g2_o21ai_1
X_4781_ _4781_/Y _4769_/Y _4781_/B VPWR VGND sg13g2_nand2b_1
XFILLER_118_104 VPWR VGND sg13g2_fill_2
Xclkload20 clkload20/Y _9662_/CLK VPWR VGND sg13g2_inv_1
XFILLER_9_294 VPWR VGND sg13g2_decap_8
X_6451_ _6516_/D _6451_/A _6451_/B _9245_/Q _6451_/D VPWR VGND sg13g2_nor4_1
X_5402_ _5402_/Y _8746_/Q _4542_/Y _5401_/Y VPWR VGND sg13g2_o21ai_1
X_9170_ _9170_/Q _9198_/CLK _9170_/D place2437/X VPWR VGND sg13g2_dfrbpq_1
Xclkload31 clkload31/Y _9630_/CLK VPWR VGND sg13g2_inv_4
X_6382_ _6382_/Y _8872_/Q _7176_/B2 _6401_/B2 _6381_/X VPWR VGND sg13g2_a22oi_1
X_5333_ _5335_/A _5329_/Y _5315_/B _5339_/B VPWR VGND sg13g2_o21ai_1
X_8121_ _8121_/Y _8121_/A _8129_/B VPWR VGND sg13g2_nand2_1
X_5264_ _5364_/C _8517_/C _9491_/Q VPWR VGND sg13g2_nand2_1
X_8052_ _8052_/Y _9033_/Q _8052_/B VPWR VGND sg13g2_nand2_1
XFILLER_114_398 VPWR VGND sg13g2_fill_2
XFILLER_96_750 VPWR VGND sg13g2_decap_8
X_7003_ _8824_/D _8824_/Q _7000_/Y _7884_/S VPWR VGND sg13g2_mux2_1
X_5195_ _5195_/Y _9866_/A _5215_/A VPWR VGND sg13g2_xnor2_1
XFILLER_56_614 VPWR VGND sg13g2_decap_8
XFILLER_83_411 VPWR VGND sg13g2_fill_1
XFILLER_68_485 VPWR VGND sg13g2_decap_8
X_8954_ _8954_/Q _9615_/CLK _8954_/D place2417/X VPWR VGND sg13g2_dfrbpq_1
XFILLER_83_466 VPWR VGND sg13g2_fill_1
XFILLER_71_639 VPWR VGND sg13g2_decap_8
X_7905_ _8966_/D _5351_/C _7904_/A _7904_/Y VPWR VGND sg13g2_o21ai_1
X_8885_ _8885_/Q _9253_/CLK _8885_/D place2463/X VPWR VGND sg13g2_dfrbpq_1
XFILLER_70_138 VPWR VGND sg13g2_decap_8
XFILLER_24_544 VPWR VGND sg13g2_fill_2
X_7836_ _7836_/Y _7836_/A _7836_/B _7836_/C _7836_/D VPWR VGND sg13g2_nor4_1
XFILLER_51_363 VPWR VGND sg13g2_fill_1
Xclkbuf_2_1__f_jtag_tck_i_regs clkbuf_leaf_1_jtag_tck_i_regs/A clkbuf_0_jtag_tck_i_regs/X
+ VPWR VGND sg13g2_buf_8
X_7767_ _7768_/D _9171_/Q _7767_/B VPWR VGND sg13g2_nor2_1
X_4979_ _4979_/Y _9401_/Q _4979_/A2 _4978_/Y VPWR VGND sg13g2_a21oi_1
X_7698_ _8918_/D _8918_/Q _7697_/Y _7774_/S VPWR VGND sg13g2_mux2_1
X_6718_ _9486_/D _9527_/Q _9486_/Q _6729_/S VPWR VGND sg13g2_mux2_1
Xclkload3 clkload3/X clkload3/A VPWR VGND sg13g2_buf_16
X_9506_ _9506_/Q _9701_/CLK _9506_/D _9506_/RESET_B VPWR VGND sg13g2_dfrbpq_1
X_6649_ _6649_/Y _6622_/C _8648_/Q _9580_/Q _6655_/B2 VPWR VGND sg13g2_a22oi_1
X_9437_ _9437_/Q _9567_/CLK _9437_/D fanout982/X VPWR VGND sg13g2_dfrbpq_1
XFILLER_50_47 VPWR VGND sg13g2_decap_8
XFILLER_118_660 VPWR VGND sg13g2_fill_1
X_9368_ _9368_/Q clkload9/A _9368_/D place2490/X VPWR VGND sg13g2_dfrbpq_1
X_9299_ _9299_/Q _9615_/CLK _9299_/D place2419/X VPWR VGND sg13g2_dfrbpq_1
XFILLER_105_332 VPWR VGND sg13g2_decap_4
X_8319_ _8319_/Y _8319_/A _8345_/B VPWR VGND sg13g2_nand2_1
XFILLER_3_448 VPWR VGND sg13g2_decap_4
Xoutput2690 master_addr_o[7] _9865_/X VPWR VGND sg13g2_buf_1
XFILLER_115_62 VPWR VGND sg13g2_fill_1
XFILLER_87_761 VPWR VGND sg13g2_fill_2
XFILLER_47_603 VPWR VGND sg13g2_fill_2
XFILLER_86_293 VPWR VGND sg13g2_decap_8
XFILLER_74_433 VPWR VGND sg13g2_decap_4
XFILLER_74_422 VPWR VGND sg13g2_fill_2
XFILLER_19_349 VPWR VGND sg13g2_fill_1
XFILLER_15_522 VPWR VGND sg13g2_decap_8
XFILLER_91_65 VPWR VGND sg13g2_fill_2
XFILLER_116_608 VPWR VGND sg13g2_decap_8
XFILLER_7_776 VPWR VGND sg13g2_decap_4
XFILLER_6_286 VPWR VGND sg13g2_decap_8
XFILLER_123_140 VPWR VGND sg13g2_decap_8
XFILLER_97_514 VPWR VGND sg13g2_decap_8
XFILLER_69_238 VPWR VGND sg13g2_decap_8
XFILLER_2_470 VPWR VGND sg13g2_decap_8
XFILLER_2_481 VPWR VGND sg13g2_fill_1
XFILLER_2_492 VPWR VGND sg13g2_fill_2
XFILLER_78_750 VPWR VGND sg13g2_decap_4
XFILLER_27_4 VPWR VGND sg13g2_fill_1
XFILLER_38_647 VPWR VGND sg13g2_decap_4
XFILLER_92_241 VPWR VGND sg13g2_decap_8
XFILLER_65_444 VPWR VGND sg13g2_fill_1
X_5951_ _9320_/D _5963_/B _5949_/Y _5950_/Y VPWR VGND sg13g2_o21ai_1
XFILLER_92_285 VPWR VGND sg13g2_fill_1
XFILLER_53_628 VPWR VGND sg13g2_fill_2
XFILLER_52_116 VPWR VGND sg13g2_decap_8
XFILLER_92_296 VPWR VGND sg13g2_fill_2
X_4902_ _4902_/Y _4994_/A _9359_/Q VPWR VGND sg13g2_nand2b_1
XFILLER_52_127 VPWR VGND sg13g2_fill_2
X_8670_ _8670_/Q _8678_/CLK _8670_/D fanout945/X VPWR VGND sg13g2_dfrbpq_1
XFILLER_46_691 VPWR VGND sg13g2_decap_8
X_5882_ _5882_/Y _5890_/A _5890_/B _5945_/B _5890_/D VPWR VGND sg13g2_nand4_1
X_7621_ _7636_/C _7621_/A _7621_/B _7621_/C VPWR VGND sg13g2_nand3_1
XFILLER_60_171 VPWR VGND sg13g2_fill_2
X_4833_ _4834_/B _4833_/A _4842_/A VPWR VGND sg13g2_nand2_1
X_7552_ _7553_/B _9321_/Q _7826_/A2 _7794_/B1 _8879_/Q _7550_/X VPWR VGND sg13g2_a221oi_1
X_4764_ _4766_/A _4820_/B _4776_/B VPWR VGND sg13g2_nand2b_1
X_7483_ _7484_/C _8845_/Q _7579_/A2 _7269_/X _7482_/A VPWR VGND sg13g2_a22oi_1
X_6503_ _6503_/Y _8893_/Q _6511_/A2 _6502_/Y _6410_/Y _6501_/Y VPWR VGND sg13g2_a221oi_1
X_4695_ _9664_/D _8731_/Q _9664_/Q _6795_/S VPWR VGND sg13g2_a21o_1
X_6434_ _6434_/Y _6433_/X _6434_/A2 _8883_/Q _6441_/A2 VPWR VGND sg13g2_a22oi_1
X_9222_ _9222_/Q clkload7/A _9222_/D place2461/X VPWR VGND sg13g2_dfrbpq_1
Xplace1921 _8515_/A _5073_/A VPWR VGND sg13g2_buf_1
Xplace1910 _8095_/C _8498_/D VPWR VGND sg13g2_buf_1
Xplace1943 _7846_/A2 _7598_/A2 VPWR VGND sg13g2_buf_1
Xplace1954 _6129_/A _6390_/A2 VPWR VGND sg13g2_buf_1
X_6365_ _6365_/Y _6365_/A _6365_/B _6365_/C _6410_/B VPWR VGND sg13g2_nand4_1
Xplace1932 _6379_/A2 _6055_/B VPWR VGND sg13g2_buf_1
X_9153_ _9153_/Q _9153_/CLK _9153_/D place2472/X VPWR VGND sg13g2_dfrbpq_1
X_5316_ _5317_/B _5316_/A _5329_/B _5329_/C _9885_/A VPWR VGND sg13g2_nand4_1
Xplace1987 _7825_/A2 _5383_/Y VPWR VGND sg13g2_buf_1
X_9084_ _9084_/Q clkload5/A _9084_/D place2485/X VPWR VGND sg13g2_dfrbpq_1
X_8104_ _9052_/D _8130_/A1 _8022_/Y _8103_/Y VPWR VGND sg13g2_o21ai_1
Xplace1965 _6962_/D _6032_/Y VPWR VGND sg13g2_buf_1
Xplace1976 _8252_/A1 _8286_/A1 VPWR VGND sg13g2_buf_1
X_6296_ _6297_/A _9370_/Q _6319_/C1 _6295_/Y _6265_/A VPWR VGND sg13g2_a22oi_1
XFILLER_115_696 VPWR VGND sg13g2_fill_1
XFILLER_88_547 VPWR VGND sg13g2_decap_4
X_5247_ _5255_/B _9874_/A _9875_/A _5280_/A _5280_/B VPWR VGND sg13g2_and4_1
Xplace1998 _5366_/B _5373_/B VPWR VGND sg13g2_buf_1
X_8035_ _9026_/D _8054_/A1 _8034_/Y _8033_/Y VPWR VGND sg13g2_o21ai_1
X_5178_ _5188_/B _5178_/A _5178_/B _9865_/A _5178_/D VPWR VGND sg13g2_nand4_1
XFILLER_56_422 VPWR VGND sg13g2_fill_2
XFILLER_29_614 VPWR VGND sg13g2_decap_8
XFILLER_84_753 VPWR VGND sg13g2_fill_2
XFILLER_84_742 VPWR VGND sg13g2_decap_8
XFILLER_56_466 VPWR VGND sg13g2_fill_1
X_8937_ _8937_/Q _9611_/CLK _8937_/D place2413/X VPWR VGND sg13g2_dfrbpq_1
XFILLER_83_274 VPWR VGND sg13g2_decap_8
XFILLER_83_263 VPWR VGND sg13g2_fill_1
XFILLER_71_414 VPWR VGND sg13g2_decap_8
XFILLER_44_639 VPWR VGND sg13g2_fill_1
XFILLER_101_42 VPWR VGND sg13g2_decap_8
XFILLER_52_661 VPWR VGND sg13g2_fill_2
XFILLER_52_650 VPWR VGND sg13g2_decap_8
X_8868_ _8868_/Q _9692_/CLK _8868_/D place2506/X VPWR VGND sg13g2_dfrbpq_1
X_8799_ _8799_/Q _9252_/CLK _8799_/D place2401/X VPWR VGND sg13g2_dfrbpq_1
X_7819_ _7819_/Y _9081_/Q _7819_/B _7819_/C VPWR VGND sg13g2_nand3b_1
XFILLER_12_558 VPWR VGND sg13g2_fill_1
Xinput2577 _8528_/D master_other_err_i VPWR VGND sg13g2_buf_1
Xinput2555 _7713_/A1 hartinfo_i[23] VPWR VGND sg13g2_buf_1
Xinput2544 _7513_/B2 hartinfo_i[13] VPWR VGND sg13g2_buf_1
Xinput2566 _7341_/B2 hartinfo_i[4] VPWR VGND sg13g2_buf_1
Xinput2599 _5998_/A master_rdata_i[29] VPWR VGND sg13g2_buf_1
Xinput2588 _5923_/A1 master_rdata_i[19] VPWR VGND sg13g2_buf_1
XFILLER_20_591 VPWR VGND sg13g2_fill_1
XFILLER_3_223 VPWR VGND sg13g2_decap_8
XFILLER_10_83 VPWR VGND sg13g2_fill_1
XFILLER_121_666 VPWR VGND sg13g2_fill_2
XFILLER_75_731 VPWR VGND sg13g2_decap_8
XFILLER_47_400 VPWR VGND sg13g2_decap_4
XFILLER_74_241 VPWR VGND sg13g2_fill_2
XFILLER_19_179 VPWR VGND sg13g2_fill_2
XFILLER_90_734 VPWR VGND sg13g2_decap_8
XFILLER_34_116 VPWR VGND sg13g2_fill_1
XFILLER_34_149 VPWR VGND sg13g2_decap_8
XFILLER_15_363 VPWR VGND sg13g2_decap_8
XFILLER_43_650 VPWR VGND sg13g2_decap_8
XFILLER_43_672 VPWR VGND sg13g2_decap_8
XFILLER_96_7 VPWR VGND sg13g2_fill_1
XFILLER_15_385 VPWR VGND sg13g2_decap_8
XFILLER_42_160 VPWR VGND sg13g2_decap_4
X_9501__2879 _9501_/RESET_B VPWR VGND sg13g2_tiehi
XFILLER_51_90 VPWR VGND sg13g2_decap_4
XFILLER_11_580 VPWR VGND sg13g2_decap_8
X_4480_ _9656_/D _8743_/Q _4480_/B _6954_/S VPWR VGND sg13g2_nand3b_1
X_6150_ _6150_/Y _8968_/Q _6410_/A _6404_/B1 _9092_/Q VPWR VGND sg13g2_a22oi_1
XFILLER_112_633 VPWR VGND sg13g2_decap_8
X_5101_ _5101_/Y _5147_/D _5101_/B _9860_/A _5175_/B VPWR VGND sg13g2_nand4_1
XFILLER_111_154 VPWR VGND sg13g2_decap_8
X_6081_ _6081_/X _8961_/Q _9023_/Q _9085_/Q _9147_/Q _6061_/A _6349_/S1 VPWR VGND
+ sg13g2_mux4_1
XFILLER_111_176 VPWR VGND sg13g2_decap_8
XFILLER_111_165 VPWR VGND sg13g2_fill_1
X_5032_ _8532_/B _5123_/B _5178_/D _8520_/C VPWR VGND sg13g2_o21ai_1
XFILLER_78_591 VPWR VGND sg13g2_fill_2
XFILLER_66_731 VPWR VGND sg13g2_fill_1
XFILLER_57_219 VPWR VGND sg13g2_decap_8
XFILLER_18_0 VPWR VGND sg13g2_decap_8
XFILLER_38_444 VPWR VGND sg13g2_decap_8
XFILLER_93_572 VPWR VGND sg13g2_fill_2
XFILLER_65_274 VPWR VGND sg13g2_fill_2
X_6983_ _6987_/B _8832_/Q _7804_/B _7744_/A VPWR VGND sg13g2_o21ai_1
X_5934_ _5934_/Y _5934_/A1 _9483_/Q _5933_/Y VPWR VGND sg13g2_o21ai_1
XFILLER_80_244 VPWR VGND sg13g2_decap_8
X_8722_ _8722_/Q _9672_/CLK _8722_/D place2442/X VPWR VGND sg13g2_dfrbpq_1
X_5865_ _5865_/X _5995_/A _5931_/A1 _5889_/S VPWR VGND sg13g2_mux2_1
X_8653_ _8653_/Q _9645_/CLK _8653_/D fanout969/X VPWR VGND sg13g2_dfrbpq_1
XFILLER_61_491 VPWR VGND sg13g2_fill_2
X_7604_ _7606_/A _7718_/A _7608_/B _9101_/Q VPWR VGND sg13g2_nor3_1
XFILLER_21_322 VPWR VGND sg13g2_decap_8
XFILLER_21_344 VPWR VGND sg13g2_fill_2
X_4816_ _4816_/X _4816_/A _4816_/B _4816_/C _4816_/D VPWR VGND sg13g2_or4_1
X_5796_ _5797_/A _9291_/Q _8579_/A2 _8579_/B1 _9488_/Q VPWR VGND sg13g2_a22oi_1
X_8584_ _9284_/D _8584_/A VPWR VGND sg13g2_inv_1
X_7535_ _7536_/B _9288_/Q _7828_/A2 _7788_/B1 _8847_/Q _7534_/Y VPWR VGND sg13g2_a221oi_1
X_4747_ _4903_/C _9340_/Q _9341_/Q VPWR VGND sg13g2_nor2_1
XFILLER_31_27 VPWR VGND sg13g2_fill_1
X_4678_ _4678_/Y _9659_/Q _8719_/Q _9662_/Q _6954_/S VPWR VGND sg13g2_a22oi_1
Xplace2430 place2430/X place2433/X VPWR VGND sg13g2_buf_1
X_7466_ _7466_/Y _7466_/A _7466_/B _7466_/C _7466_/D VPWR VGND sg13g2_nor4_1
Xplace2441 place2441/X place2442/X VPWR VGND sg13g2_buf_1
X_7397_ _8903_/D _8903_/Q _7396_/Y _7848_/S VPWR VGND sg13g2_mux2_1
Xplace2452 place2452/X place2453/X VPWR VGND sg13g2_buf_1
X_6417_ _6417_/X _9005_/Q _9067_/Q _9129_/Q _9191_/Q _6440_/S0 _6440_/S1 VPWR VGND
+ sg13g2_mux4_1
Xplace2474 place2474/X place2475/X VPWR VGND sg13g2_buf_1
X_9205_ _9205_/Q _9251_/CLK _9205_/D place2461/X VPWR VGND sg13g2_dfrbpq_1
Xplace2463 place2463/X place2476/X VPWR VGND sg13g2_buf_1
XFILLER_122_419 VPWR VGND sg13g2_fill_2
X_9136_ _9136_/Q _9198_/CLK _9136_/D place2439/X VPWR VGND sg13g2_dfrbpq_1
Xplace2485 place2485/X place2486/X VPWR VGND sg13g2_buf_1
XFILLER_1_727 VPWR VGND sg13g2_fill_2
Xplace2496 place2496/X place2506/X VPWR VGND sg13g2_buf_1
X_6348_ _6348_/Y _6365_/A _6365_/C _6365_/B _6348_/D VPWR VGND sg13g2_nand4_1
Xhold3110 _4680_/B1 _9661_/Q VPWR VGND sg13g2_dlygate4sd3_1
Xplace1773 _6656_/A1 _6663_/A1 VPWR VGND sg13g2_buf_1
Xplace1795 _5272_/A _5316_/A VPWR VGND sg13g2_buf_1
Xhold3121 _5683_/B2 _8595_/Q VPWR VGND sg13g2_dlygate4sd3_1
Xplace1784 _8299_/B _8345_/B VPWR VGND sg13g2_buf_1
Xhold3132 _5621_/A _9421_/Q VPWR VGND sg13g2_dlygate4sd3_1
Xhold3165 _6793_/B1 _9549_/Q VPWR VGND sg13g2_dlygate4sd3_1
Xhold3154 _8281_/A _9141_/Q VPWR VGND sg13g2_dlygate4sd3_1
X_9067_ _9067_/Q _9254_/CLK _9067_/D place2457/X VPWR VGND sg13g2_dfrbpq_1
Xhold3143 _8067_/A _9039_/Q VPWR VGND sg13g2_dlygate4sd3_1
X_6279_ _6279_/X _6279_/A _6279_/B _6279_/C VPWR VGND sg13g2_and3_1
Xhold3176 _8486_/B _9248_/Q VPWR VGND sg13g2_dlygate4sd3_1
XFILLER_88_399 VPWR VGND sg13g2_fill_1
Xhold3187 _4701_/A _8740_/Q VPWR VGND sg13g2_dlygate4sd3_1
Xhold3198 _6800_/B1 _9553_/Q VPWR VGND sg13g2_dlygate4sd3_1
XFILLER_57_720 VPWR VGND sg13g2_decap_4
XFILLER_29_411 VPWR VGND sg13g2_decap_8
XFILLER_29_422 VPWR VGND sg13g2_fill_2
X_8018_ _9019_/D _5373_/C _8017_/A _8017_/Y VPWR VGND sg13g2_o21ai_1
XFILLER_48_219 VPWR VGND sg13g2_fill_1
XFILLER_57_786 VPWR VGND sg13g2_fill_1
XFILLER_56_79 VPWR VGND sg13g2_decap_8
XFILLER_56_285 VPWR VGND sg13g2_fill_2
XFILLER_112_85 VPWR VGND sg13g2_fill_2
XFILLER_72_778 VPWR VGND sg13g2_decap_8
XFILLER_72_34 VPWR VGND sg13g2_fill_1
XFILLER_71_255 VPWR VGND sg13g2_fill_1
XFILLER_16_149 VPWR VGND sg13g2_decap_8
XFILLER_32_609 VPWR VGND sg13g2_decap_8
XFILLER_71_277 VPWR VGND sg13g2_fill_2
XFILLER_24_160 VPWR VGND sg13g2_decap_8
XFILLER_24_171 VPWR VGND sg13g2_fill_1
XFILLER_25_694 VPWR VGND sg13g2_decap_8
XFILLER_8_315 VPWR VGND sg13g2_decap_8
XFILLER_122_0 VPWR VGND sg13g2_decap_8
XFILLER_4_543 VPWR VGND sg13g2_decap_8
XFILLER_79_300 VPWR VGND sg13g2_fill_1
Xclkbuf_regs_0_clk_jtg clkbuf_regs_0_clk_jtg/X delaybuf_4_clk_jtg/X VPWR VGND sg13g2_buf_8
XFILLER_97_75 VPWR VGND sg13g2_decap_8
XFILLER_48_720 VPWR VGND sg13g2_decap_8
XFILLER_75_550 VPWR VGND sg13g2_fill_2
XFILLER_50_406 VPWR VGND sg13g2_decap_4
XFILLER_62_277 VPWR VGND sg13g2_decap_8
X_5650_ _8616_/D _5650_/A VPWR VGND sg13g2_inv_1
X_4601_ _4602_/B _9663_/Q _8731_/Q VPWR VGND sg13g2_nor2b_1
XFILLER_31_664 VPWR VGND sg13g2_decap_8
XFILLER_31_675 VPWR VGND sg13g2_fill_2
X_5581_ _8648_/D _5580_/Y _5579_/Y _5581_/B1 VPWR VGND sg13g2_a21oi_1
XFILLER_30_185 VPWR VGND sg13g2_fill_2
XFILLER_117_725 VPWR VGND sg13g2_fill_1
XFILLER_116_202 VPWR VGND sg13g2_decap_8
X_7320_ _7322_/A _9277_/Q _7557_/A2 _7557_/B1 _9309_/Q VPWR VGND sg13g2_a22oi_1
X_4532_ _8448_/A _7269_/A _4532_/B _4562_/D _7032_/B VPWR VGND sg13g2_nand4_1
XFILLER_7_381 VPWR VGND sg13g2_fill_1
XFILLER_7_370 VPWR VGND sg13g2_decap_8
X_7251_ _7253_/C _7278_/C _8990_/Q _7295_/C VPWR VGND sg13g2_nor3_1
X_4463_ _4729_/A _8734_/Q _9680_/Q VPWR VGND sg13g2_nor2b_1
XFILLER_116_257 VPWR VGND sg13g2_decap_8
X_6202_ _6202_/X _8974_/Q _9036_/Q _9098_/Q _9160_/Q _6440_/S0 _6440_/S1 VPWR VGND
+ sg13g2_mux4_1
X_4394_ _8675_/D _4394_/A _5438_/B_N VPWR VGND sg13g2_nor2b_1
X_7182_ _7182_/Y _7236_/A _7182_/B _7236_/C _7182_/D VPWR VGND sg13g2_nand4_1
XFILLER_112_452 VPWR VGND sg13g2_decap_4
XFILLER_97_141 VPWR VGND sg13g2_fill_1
XFILLER_86_804 VPWR VGND sg13g2_fill_1
X_6133_ _6133_/X _6224_/A _9230_/Q _6247_/C _6369_/D VPWR VGND sg13g2_and4_1
XFILLER_112_496 VPWR VGND sg13g2_decap_8
XFILLER_100_636 VPWR VGND sg13g2_fill_2
XFILLER_100_625 VPWR VGND sg13g2_decap_8
X_6064_ _6071_/D _6064_/A _6064_/B _7132_/B _6064_/D VPWR VGND sg13g2_or4_1
X_5015_ _5015_/Y _4994_/A _9375_/Q VPWR VGND sg13g2_nand2b_1
XFILLER_66_572 VPWR VGND sg13g2_fill_1
XFILLER_26_403 VPWR VGND sg13g2_fill_1
XFILLER_39_775 VPWR VGND sg13g2_fill_2
XFILLER_26_27 VPWR VGND sg13g2_decap_4
X_6966_ _6966_/Y _4452_/B _6032_/Y _7818_/B VPWR VGND sg13g2_a21oi_1
X_5917_ _5917_/Y _5917_/A _5917_/B _5925_/C VPWR VGND sg13g2_nand3_1
X_8705_ _8705_/Q _9649_/CLK _8716_/Q fanout974/X VPWR VGND sg13g2_dfrbpq_1
XFILLER_81_597 VPWR VGND sg13g2_fill_1
XFILLER_13_119 VPWR VGND sg13g2_fill_1
X_6897_ _6897_/X _8922_/Q _8954_/Q _6901_/S VPWR VGND sg13g2_mux2_1
X_9685_ _9685_/Q _9689_/CLK _9685_/D fanout962/X VPWR VGND sg13g2_dfrbpq_1
X_8636_ _8636_/Q _9449_/CLK _8636_/D fanout970/X VPWR VGND sg13g2_dfrbpq_1
X_5848_ _5848_/Y _5837_/A2 _9473_/Q VPWR VGND sg13g2_nand2b_1
X_5779_ _5779_/X _9320_/Q _9336_/Q _9312_/Q _9328_/Q _5938_/A _5843_/A2 VPWR VGND
+ sg13g2_mux4_1
X_8567_ _8567_/Y _8577_/A _8577_/B _9276_/Q VPWR VGND sg13g2_nand3_1
XFILLER_21_196 VPWR VGND sg13g2_fill_1
X_7518_ _8909_/D _8909_/Q _7517_/Y _7793_/S VPWR VGND sg13g2_mux2_1
XFILLER_108_758 VPWR VGND sg13g2_decap_8
X_8498_ _8498_/Y _9499_/Q _8498_/B _8498_/C _8498_/D VPWR VGND sg13g2_nand4_1
X_9605__2785 _9605_/RESET_B VPWR VGND sg13g2_tiehi
Xplace2282 _6534_/B _9408_/Q VPWR VGND sg13g2_buf_1
Xplace2260 _7644_/A _7820_/A VPWR VGND sg13g2_buf_1
X_7449_ _7453_/B _9062_/Q _7485_/B VPWR VGND sg13g2_nor2_1
Xplace2271 _7818_/B _7819_/B VPWR VGND sg13g2_buf_1
Xplace2293 _4842_/A _9340_/Q VPWR VGND sg13g2_buf_1
XFILLER_77_804 VPWR VGND sg13g2_fill_1
X_9119_ _9119_/Q clkload5/A _9119_/D place2484/X VPWR VGND sg13g2_dfrbpq_1
XFILLER_107_96 VPWR VGND sg13g2_fill_2
XFILLER_89_697 VPWR VGND sg13g2_decap_4
XFILLER_76_314 VPWR VGND sg13g2_decap_8
XFILLER_67_56 VPWR VGND sg13g2_fill_1
XFILLER_67_45 VPWR VGND sg13g2_decap_8
XFILLER_67_34 VPWR VGND sg13g2_fill_2
XFILLER_76_347 VPWR VGND sg13g2_fill_1
XFILLER_17_403 VPWR VGND sg13g2_decap_8
XFILLER_123_84 VPWR VGND sg13g2_decap_8
XFILLER_91_328 VPWR VGND sg13g2_decap_4
XFILLER_84_391 VPWR VGND sg13g2_decap_8
XFILLER_57_583 VPWR VGND sg13g2_decap_8
XFILLER_45_734 VPWR VGND sg13g2_decap_4
XFILLER_72_553 VPWR VGND sg13g2_fill_2
XFILLER_60_737 VPWR VGND sg13g2_decap_8
XFILLER_13_675 VPWR VGND sg13g2_fill_2
XFILLER_59_7 VPWR VGND sg13g2_decap_4
XFILLER_4_340 VPWR VGND sg13g2_decap_4
XFILLER_107_780 VPWR VGND sg13g2_decap_8
XFILLER_99_428 VPWR VGND sg13g2_fill_2
XFILLER_79_141 VPWR VGND sg13g2_decap_8
XFILLER_79_130 VPWR VGND sg13g2_decap_8
XFILLER_68_804 VPWR VGND sg13g2_fill_1
XFILLER_122_794 VPWR VGND sg13g2_fill_1
XFILLER_122_783 VPWR VGND sg13g2_decap_8
XFILLER_67_325 VPWR VGND sg13g2_decap_8
XFILLER_82_306 VPWR VGND sg13g2_decap_8
XFILLER_48_561 VPWR VGND sg13g2_decap_8
XFILLER_36_701 VPWR VGND sg13g2_decap_8
XFILLER_63_531 VPWR VGND sg13g2_decap_8
X_6820_ _9568_/D _9601_/Q _9568_/Q _6836_/S VPWR VGND sg13g2_mux2_1
XFILLER_63_564 VPWR VGND sg13g2_decap_4
XFILLER_50_258 VPWR VGND sg13g2_decap_8
X_6751_ _9510_/D _9510_/Q _9420_/Q _6756_/S VPWR VGND sg13g2_mux2_1
X_6682_ _9458_/D _9458_/Q _9460_/Q _6682_/S VPWR VGND sg13g2_mux2_1
XFILLER_85_0 VPWR VGND sg13g2_decap_8
X_5702_ _8732_/D _9664_/D _5702_/B VPWR VGND sg13g2_and2_1
X_9470_ _9470_/Q _9501_/CLK _9470_/D _9470_/RESET_B VPWR VGND sg13g2_dfrbpq_1
X_8421_ _9214_/D _5361_/C _8432_/A _8420_/Y VPWR VGND sg13g2_o21ai_1
X_5633_ _8619_/D _5633_/A VPWR VGND sg13g2_inv_1
X_5564_ _5564_/Y _5585_/A _5585_/B _8644_/Q _5585_/D VPWR VGND sg13g2_nand4_1
X_8352_ _9176_/D _5344_/C _8355_/A _8351_/Y VPWR VGND sg13g2_o21ai_1
X_7303_ _7304_/A _9308_/Q _7826_/A2 _7533_/B1 _8866_/Q _7262_/X VPWR VGND sg13g2_a221oi_1
X_4515_ _8494_/A _8498_/B _8498_/C _8498_/D VPWR VGND sg13g2_nand3_1
X_8283_ _8283_/Y _9142_/Q _8287_/B VPWR VGND sg13g2_nand2_1
X_5495_ _5496_/B _9705_/Q _6541_/A _6541_/B VPWR VGND sg13g2_nand3_1
X_7234_ _7234_/Y _7238_/A1 _7232_/Y _7233_/Y VPWR VGND sg13g2_a21oi_1
X_4446_ _4447_/D _4446_/A _4446_/B VPWR VGND sg13g2_nand2_1
X_4377_ _4378_/B _9210_/Q _9644_/Q _9647_/Q _6743_/C VPWR VGND sg13g2_nor4_1
X_7165_ _7165_/Y _7165_/A _7172_/B _7207_/C _7179_/D VPWR VGND sg13g2_nand4_1
XFILLER_98_483 VPWR VGND sg13g2_decap_8
X_6116_ _6117_/B _6438_/A _6080_/B _6114_/Y VPWR VGND sg13g2_o21ai_1
X_7096_ _7096_/Y _7198_/A _7210_/D _7123_/C VPWR VGND sg13g2_nand3_1
XFILLER_100_466 VPWR VGND sg13g2_decap_4
XFILLER_86_678 VPWR VGND sg13g2_fill_2
X_6047_ _6049_/C _6047_/A _6046_/Y VPWR VGND sg13g2_nor2b_1
XFILLER_39_550 VPWR VGND sg13g2_fill_1
XFILLER_27_734 VPWR VGND sg13g2_fill_2
XFILLER_39_572 VPWR VGND sg13g2_decap_8
XFILLER_66_391 VPWR VGND sg13g2_decap_8
XFILLER_27_767 VPWR VGND sg13g2_decap_8
XFILLER_27_778 VPWR VGND sg13g2_fill_2
X_7998_ _9009_/D _5363_/C _8011_/A _7997_/Y VPWR VGND sg13g2_o21ai_1
XFILLER_42_715 VPWR VGND sg13g2_decap_8
X_6949_ _9633_/D _6545_/Y _6946_/Y _6948_/Y VPWR VGND sg13g2_o21ai_1
X_9668_ _9668_/Q _9672_/CLK _9668_/D place2441/X VPWR VGND sg13g2_dfrbpq_1
XFILLER_10_623 VPWR VGND sg13g2_fill_1
X_8619_ _8619_/Q _9689_/CLK _8619_/D fanout949/X VPWR VGND sg13g2_dfrbpq_1
X_9599_ _9599_/Q _9620_/CLK _9599_/D _9599_/RESET_B VPWR VGND sg13g2_dfrbpq_1
XFILLER_108_544 VPWR VGND sg13g2_decap_8
XFILLER_123_525 VPWR VGND sg13g2_decap_8
Xplace2090 _5929_/B _5843_/A2 VPWR VGND sg13g2_buf_1
XFILLER_108_599 VPWR VGND sg13g2_fill_2
XFILLER_103_260 VPWR VGND sg13g2_decap_8
XFILLER_77_645 VPWR VGND sg13g2_fill_2
XFILLER_49_347 VPWR VGND sg13g2_fill_1
XFILLER_1_387 VPWR VGND sg13g2_fill_1
XFILLER_94_21 VPWR VGND sg13g2_fill_2
XFILLER_57_380 VPWR VGND sg13g2_decap_8
XFILLER_17_244 VPWR VGND sg13g2_fill_2
XFILLER_72_361 VPWR VGND sg13g2_decap_8
XFILLER_72_350 VPWR VGND sg13g2_decap_8
XFILLER_13_461 VPWR VGND sg13g2_decap_4
XFILLER_20_409 VPWR VGND sg13g2_fill_2
XFILLER_13_483 VPWR VGND sg13g2_decap_8
XFILLER_118_319 VPWR VGND sg13g2_fill_1
X_5280_ _5280_/Y _5280_/A _5280_/B _5291_/C _5291_/D VPWR VGND sg13g2_nand4_1
X_4300_ _7025_/A _9221_/D VPWR VGND sg13g2_inv_1
XFILLER_102_709 VPWR VGND sg13g2_fill_1
XFILLER_68_656 VPWR VGND sg13g2_decap_8
XFILLER_68_645 VPWR VGND sg13g2_decap_4
XFILLER_110_775 VPWR VGND sg13g2_fill_1
X_8970_ _8970_/Q clkload4/A _8970_/D place2481/X VPWR VGND sg13g2_dfrbpq_1
XFILLER_82_114 VPWR VGND sg13g2_fill_2
X_7921_ _8973_/D _5358_/C _7956_/A _7919_/Y VPWR VGND sg13g2_o21ai_1
XFILLER_82_158 VPWR VGND sg13g2_decap_8
XFILLER_91_681 VPWR VGND sg13g2_decap_8
X_7852_ _8929_/D _8929_/Q _7288_/Y _7885_/S VPWR VGND sg13g2_mux2_1
XFILLER_36_575 VPWR VGND sg13g2_decap_8
XFILLER_36_586 VPWR VGND sg13g2_fill_1
XFILLER_91_692 VPWR VGND sg13g2_fill_1
X_6803_ _6804_/D _8741_/D _6803_/B VPWR VGND sg13g2_nor2_1
X_7783_ _7783_/Y _9079_/Q _7783_/B _7783_/C VPWR VGND sg13g2_nand3b_1
XFILLER_23_247 VPWR VGND sg13g2_decap_8
X_4995_ _5010_/B _4924_/A _4774_/Y _4995_/S VPWR VGND sg13g2_mux2_1
X_6734_ _9502_/D _9543_/Q _9502_/Q _6736_/S VPWR VGND sg13g2_mux2_1
X_9522_ _9522_/Q _9587_/CLK _9522_/D _9522_/RESET_B VPWR VGND sg13g2_dfrbpq_1
XFILLER_23_17 VPWR VGND sg13g2_decap_8
XFILLER_23_258 VPWR VGND sg13g2_decap_8
X_9453_ _9453_/Q _9645_/CLK _9453_/D fanout979/X VPWR VGND sg13g2_dfrbpq_1
X_8404_ _9202_/D _5370_/C _8403_/A _8403_/Y VPWR VGND sg13g2_o21ai_1
X_6665_ _6665_/X _6672_/A _9585_/Q _6672_/C VPWR VGND sg13g2_or3_1
X_6596_ _9430_/D _6663_/A1 _6595_/Y _6594_/Y VPWR VGND sg13g2_o21ai_1
X_5616_ _5616_/Y _8661_/Q _5498_/X _5500_/Y _8660_/Q VPWR VGND sg13g2_a22oi_1
X_9384_ _9384_/Q clkload9/A _9384_/D place2503/X VPWR VGND sg13g2_dfrbpq_1
X_5547_ _5547_/Y _9435_/Q _5579_/B _5589_/B1 _8637_/Q VPWR VGND sg13g2_a22oi_1
XFILLER_105_503 VPWR VGND sg13g2_fill_2
X_8335_ _8335_/Y _8335_/A _8345_/B VPWR VGND sg13g2_nand2_1
X_8266_ _9133_/D _8563_/D _8071_/Y _8265_/Y VPWR VGND sg13g2_o21ai_1
X_5478_ _5478_/Y _6566_/A _6948_/B _6566_/D VPWR VGND sg13g2_nor3_1
X_9514__2866 _9514_/RESET_B VPWR VGND sg13g2_tiehi
X_7217_ _8888_/D _7216_/Y _8888_/Q _7239_/S VPWR VGND sg13g2_mux2_1
X_4429_ _4429_/Y _6090_/A _5391_/B VPWR VGND sg13g2_nand2_1
X_8197_ _8197_/Y _8197_/A _8197_/B VPWR VGND sg13g2_nand2_1
XFILLER_58_122 VPWR VGND sg13g2_fill_2
XFILLER_58_100 VPWR VGND sg13g2_decap_4
X_7148_ _8868_/D _6975_/X _7146_/Y _7147_/Y VPWR VGND sg13g2_o21ai_1
XFILLER_101_753 VPWR VGND sg13g2_fill_1
X_7079_ _8846_/D _7078_/Y _8846_/Q _7085_/S VPWR VGND sg13g2_mux2_1
XFILLER_100_296 VPWR VGND sg13g2_decap_8
XFILLER_64_79 VPWR VGND sg13g2_decap_8
XFILLER_54_372 VPWR VGND sg13g2_decap_8
XFILLER_27_575 VPWR VGND sg13g2_decap_8
XFILLER_14_247 VPWR VGND sg13g2_decap_8
XFILLER_27_597 VPWR VGND sg13g2_decap_8
XFILLER_120_63 VPWR VGND sg13g2_decap_4
XFILLER_30_707 VPWR VGND sg13g2_fill_1
XFILLER_23_781 VPWR VGND sg13g2_decap_4
XFILLER_80_89 VPWR VGND sg13g2_decap_4
XFILLER_22_291 VPWR VGND sg13g2_decap_8
XFILLER_13_61 VPWR VGND sg13g2_fill_1
XFILLER_89_21 VPWR VGND sg13g2_decap_8
XFILLER_6_468 VPWR VGND sg13g2_fill_2
XFILLER_2_652 VPWR VGND sg13g2_fill_2
XFILLER_1_195 VPWR VGND sg13g2_decap_8
XFILLER_77_497 VPWR VGND sg13g2_decap_8
XFILLER_65_626 VPWR VGND sg13g2_fill_1
XFILLER_64_114 VPWR VGND sg13g2_fill_2
XFILLER_64_158 VPWR VGND sg13g2_fill_1
XFILLER_38_91 VPWR VGND sg13g2_decap_8
XFILLER_92_478 VPWR VGND sg13g2_decap_8
XFILLER_18_564 VPWR VGND sg13g2_fill_1
XFILLER_33_501 VPWR VGND sg13g2_decap_8
XFILLER_45_350 VPWR VGND sg13g2_decap_8
XFILLER_33_534 VPWR VGND sg13g2_decap_4
X_4780_ _4781_/B _9378_/Q _4770_/Y _4779_/Y VPWR VGND sg13g2_a21oi_1
XFILLER_33_578 VPWR VGND sg13g2_decap_8
X_9564__2826 _9564_/RESET_B VPWR VGND sg13g2_tiehi
XFILLER_20_206 VPWR VGND sg13g2_decap_8
XFILLER_20_239 VPWR VGND sg13g2_fill_1
X_9600__2790 _9600_/RESET_B VPWR VGND sg13g2_tiehi
Xclkload10 clkload10/Y _9692_/CLK VPWR VGND sg13g2_inv_4
X_6450_ _9397_/D _6484_/S _6449_/Y _6448_/Y VPWR VGND sg13g2_o21ai_1
Xclkload21 clkload21/Y _9621_/CLK VPWR VGND sg13g2_inv_1
X_5401_ _5401_/Y _5401_/A _5404_/C _8515_/A _8515_/B VPWR VGND sg13g2_nand4_1
Xclkload32 clkload32/Y _8678_/CLK VPWR VGND sg13g2_inv_8
X_6381_ _6381_/X _8998_/Q _9060_/Q _9122_/Q _9184_/Q _6381_/S0 _6381_/S1 VPWR VGND
+ sg13g2_mux4_1
X_5332_ _5374_/C _8414_/C _9501_/Q VPWR VGND sg13g2_nand2_1
X_8120_ _9060_/D _8120_/A1 _8042_/Y _8119_/Y VPWR VGND sg13g2_o21ai_1
XFILLER_48_0 VPWR VGND sg13g2_decap_8
XFILLER_88_718 VPWR VGND sg13g2_fill_1
XFILLER_87_206 VPWR VGND sg13g2_decap_4
X_5263_ _8771_/D _5288_/B2 _8487_/A2 _5262_/Y VPWR VGND sg13g2_o21ai_1
X_8051_ _9032_/D _8054_/A1 _8050_/Y _8049_/Y VPWR VGND sg13g2_o21ai_1
X_7002_ _8514_/B _9258_/Q _7002_/B _7002_/C _7002_/D VPWR VGND sg13g2_and4_1
X_5194_ _5316_/A _5192_/Y _5139_/B _5190_/Y VPWR VGND sg13g2_o21ai_1
X_8953_ _8953_/Q _9615_/CLK _8953_/D place2418/X VPWR VGND sg13g2_dfrbpq_1
XFILLER_71_618 VPWR VGND sg13g2_decap_8
X_8884_ _8884_/Q _9407_/CLK _8884_/D place2459/X VPWR VGND sg13g2_dfrbpq_1
X_7904_ _7904_/Y _7904_/A _8966_/Q _8365_/C VPWR VGND sg13g2_nand3_1
XFILLER_34_27 VPWR VGND sg13g2_fill_2
XFILLER_36_383 VPWR VGND sg13g2_fill_2
X_7835_ _7836_/D _9206_/Q _7670_/B _7667_/A VPWR VGND sg13g2_o21ai_1
XFILLER_12_729 VPWR VGND sg13g2_fill_1
X_7766_ _7768_/B _7803_/A _9140_/Q _7802_/C VPWR VGND sg13g2_nor3_1
XFILLER_11_228 VPWR VGND sg13g2_fill_2
X_4978_ _4978_/Y _4813_/A _4903_/D _4834_/Y _4948_/Y _4899_/C VPWR VGND sg13g2_a221oi_1
X_9505_ _9505_/Q _9511_/CLK _9505_/D _9505_/RESET_B VPWR VGND sg13g2_dfrbpq_1
X_6717_ _9485_/D _9526_/Q _9485_/Q _6729_/S VPWR VGND sg13g2_mux2_1
X_7697_ _7697_/Y _7829_/A _7696_/Y VPWR VGND sg13g2_nor2b_1
XFILLER_20_740 VPWR VGND sg13g2_fill_2
XFILLER_20_751 VPWR VGND sg13g2_decap_8
Xclkload4 clkload4/Y clkload4/A VPWR VGND sg13g2_inv_8
X_6648_ _6648_/Y _9446_/Q _6654_/B VPWR VGND sg13g2_nand2_1
X_9436_ _9436_/Q _9567_/CLK _9436_/D fanout982/X VPWR VGND sg13g2_dfrbpq_1
XFILLER_50_26 VPWR VGND sg13g2_decap_8
X_9367_ _9367_/Q _9406_/CLK _9367_/D place2491/X VPWR VGND sg13g2_dfrbpq_1
X_6579_ _9425_/D _6670_/A1 _6578_/Y _6577_/Y VPWR VGND sg13g2_o21ai_1
X_8318_ _9159_/D _7028_/D _7920_/Y _8317_/Y VPWR VGND sg13g2_o21ai_1
X_9298_ _9298_/Q _9304_/CLK _9298_/D place2410/X VPWR VGND sg13g2_dfrbpq_1
XFILLER_59_24 VPWR VGND sg13g2_fill_2
XFILLER_105_355 VPWR VGND sg13g2_decap_4
Xoutput2680 master_addr_o[27] _9885_/X VPWR VGND sg13g2_buf_1
Xoutput2691 master_addr_o[8] _9866_/X VPWR VGND sg13g2_buf_1
XFILLER_79_718 VPWR VGND sg13g2_decap_8
XFILLER_78_217 VPWR VGND sg13g2_decap_4
XFILLER_59_35 VPWR VGND sg13g2_fill_2
X_8249_ _8249_/Y _8249_/A _8285_/B VPWR VGND sg13g2_nand2_1
XFILLER_115_52 VPWR VGND sg13g2_fill_2
XFILLER_101_583 VPWR VGND sg13g2_decap_8
XFILLER_87_784 VPWR VGND sg13g2_fill_2
XFILLER_47_648 VPWR VGND sg13g2_fill_1
XFILLER_47_615 VPWR VGND sg13g2_decap_8
XFILLER_46_103 VPWR VGND sg13g2_fill_2
XFILLER_62_607 VPWR VGND sg13g2_decap_8
XFILLER_47_659 VPWR VGND sg13g2_fill_2
XFILLER_15_501 VPWR VGND sg13g2_decap_8
XFILLER_55_681 VPWR VGND sg13g2_decap_8
XFILLER_42_331 VPWR VGND sg13g2_decap_8
XFILLER_42_353 VPWR VGND sg13g2_decap_4
XFILLER_10_261 VPWR VGND sg13g2_decap_8
XFILLER_109_661 VPWR VGND sg13g2_fill_2
XFILLER_6_298 VPWR VGND sg13g2_decap_4
XFILLER_65_423 VPWR VGND sg13g2_fill_2
XFILLER_65_401 VPWR VGND sg13g2_decap_8
XFILLER_38_615 VPWR VGND sg13g2_fill_1
XFILLER_93_765 VPWR VGND sg13g2_fill_1
XFILLER_93_743 VPWR VGND sg13g2_fill_1
XFILLER_92_220 VPWR VGND sg13g2_decap_8
X_9618__2772 _9618_/RESET_B VPWR VGND sg13g2_tiehi
XFILLER_1_42 VPWR VGND sg13g2_decap_8
X_5950_ _5950_/Y _9320_/Q _5963_/B VPWR VGND sg13g2_nand2_1
XFILLER_93_776 VPWR VGND sg13g2_fill_2
XFILLER_65_467 VPWR VGND sg13g2_decap_4
XFILLER_80_437 VPWR VGND sg13g2_fill_2
XFILLER_52_139 VPWR VGND sg13g2_decap_8
XFILLER_18_383 VPWR VGND sg13g2_decap_4
XFILLER_18_394 VPWR VGND sg13g2_decap_4
X_4901_ _4901_/Y _5000_/B1 _4897_/Y _4900_/Y VPWR VGND sg13g2_o21ai_1
X_5881_ _5881_/X _6001_/A _5946_/B2 _5889_/S VPWR VGND sg13g2_mux2_1
X_7620_ _7621_/C _9216_/Q _8413_/B _7808_/B1 _8803_/Q VPWR VGND sg13g2_a22oi_1
XFILLER_61_651 VPWR VGND sg13g2_decap_8
XFILLER_61_640 VPWR VGND sg13g2_fill_1
X_4832_ _4832_/Y _4844_/B _4791_/B _4937_/C VPWR VGND sg13g2_o21ai_1
X_7551_ _7553_/C _9267_/Q _7551_/B VPWR VGND sg13g2_nand2_1
X_4763_ _4842_/B _4827_/B _4923_/A VPWR VGND sg13g2_nor2b_1
XFILLER_119_436 VPWR VGND sg13g2_fill_2
X_4694_ _9665_/D _4694_/A _6795_/S VPWR VGND sg13g2_nor2_1
X_7482_ _7515_/A _7482_/A _8498_/B _7482_/C VPWR VGND sg13g2_nand3_1
X_6502_ _6502_/Y _4425_/Y _6315_/Y _6399_/D VPWR VGND sg13g2_o21ai_1
X_6433_ _6433_/X _9009_/Q _9071_/Q _9133_/Q _9195_/Q _6480_/S0 _6480_/S1 VPWR VGND
+ sg13g2_mux4_1
X_9221_ _9221_/Q _9252_/CLK _9221_/D place2403/X VPWR VGND sg13g2_dfrbpq_1
Xplace1911 _8498_/D _8092_/C VPWR VGND sg13g2_buf_1
Xplace1900 _6415_/A1 _6328_/C VPWR VGND sg13g2_buf_1
Xplace1944 _7579_/A2 _7598_/A2 VPWR VGND sg13g2_buf_1
X_6364_ _6364_/Y _8869_/Q _6375_/A2 _6363_/X _6390_/A2 VPWR VGND sg13g2_a22oi_1
Xplace1955 _6390_/A2 _6042_/Y VPWR VGND sg13g2_buf_1
X_9152_ _9152_/Q _9183_/CLK _9152_/D place2469/X VPWR VGND sg13g2_dfrbpq_1
Xplace1933 _5000_/B1 _4899_/C VPWR VGND sg13g2_buf_1
Xplace1922 _7221_/C _7207_/C VPWR VGND sg13g2_buf_1
XFILLER_103_804 VPWR VGND sg13g2_fill_1
Xplace1966 _7826_/A2 _5828_/Y VPWR VGND sg13g2_buf_1
X_5315_ _5315_/Y _5315_/A _5315_/B VPWR VGND sg13g2_nor2_1
Xplace1988 _7694_/B _5383_/Y VPWR VGND sg13g2_buf_1
Xplace1977 _8286_/A1 _8284_/A1 VPWR VGND sg13g2_buf_1
X_9083_ _9083_/Q clkload5/A _9083_/D place2485/X VPWR VGND sg13g2_dfrbpq_1
X_8103_ _8103_/Y _8103_/A _8129_/B VPWR VGND sg13g2_nand2_1
X_6295_ _6295_/Y _6291_/Y _6292_/Y _6294_/Y VPWR VGND sg13g2_o21ai_1
XFILLER_102_336 VPWR VGND sg13g2_fill_2
X_5246_ _5361_/C _8517_/C _9488_/Q VPWR VGND sg13g2_nand2_1
XFILLER_88_537 VPWR VGND sg13g2_fill_2
Xplace1999 _5375_/B _5373_/B VPWR VGND sg13g2_buf_1
X_8034_ _8034_/Y _8039_/A _8039_/B _8039_/C _8034_/D VPWR VGND sg13g2_nand4_1
XFILLER_29_27 VPWR VGND sg13g2_fill_2
X_5177_ _5185_/B _5177_/A _8517_/B _9865_/A VPWR VGND sg13g2_nand3_1
XFILLER_56_401 VPWR VGND sg13g2_decap_8
XFILLER_29_626 VPWR VGND sg13g2_decap_4
XFILLER_56_445 VPWR VGND sg13g2_decap_8
X_8936_ _8936_/Q _9603_/CLK _8936_/D place2413/X VPWR VGND sg13g2_dfrbpq_1
XFILLER_84_776 VPWR VGND sg13g2_decap_4
X_8867_ _8867_/Q _9692_/CLK _8867_/D place2506/X VPWR VGND sg13g2_dfrbpq_1
XFILLER_36_191 VPWR VGND sg13g2_fill_2
X_8798_ _8798_/Q _9252_/CLK _8798_/D place2403/X VPWR VGND sg13g2_dfrbpq_1
XFILLER_12_515 VPWR VGND sg13g2_decap_8
X_7818_ _7822_/B _7819_/C _7818_/B _8988_/Q VPWR VGND sg13g2_nor3_1
XFILLER_101_98 VPWR VGND sg13g2_decap_8
X_7749_ _7749_/Y _7749_/A _7749_/B _7749_/C _7749_/D VPWR VGND sg13g2_nor4_1
XFILLER_51_183 VPWR VGND sg13g2_decap_4
XFILLER_12_548 VPWR VGND sg13g2_fill_1
Xinput2556 _7730_/A hartinfo_i[24] VPWR VGND sg13g2_buf_1
Xinput2545 _7532_/B2 hartinfo_i[14] VPWR VGND sg13g2_buf_1
Xinput2567 _7359_/B2 hartinfo_i[5] VPWR VGND sg13g2_buf_1
Xinput2589 _5842_/A2 master_rdata_i[1] VPWR VGND sg13g2_buf_1
Xinput2578 _5833_/B1 master_rdata_i[0] VPWR VGND sg13g2_buf_1
X_9419_ _9419_/Q _9511_/CLK _9419_/D fanout958/X VPWR VGND sg13g2_dfrbpq_1
XFILLER_4_758 VPWR VGND sg13g2_fill_2
XFILLER_106_686 VPWR VGND sg13g2_fill_2
XFILLER_106_675 VPWR VGND sg13g2_decap_8
XFILLER_106_697 VPWR VGND sg13g2_fill_1
XFILLER_105_185 VPWR VGND sg13g2_fill_2
XFILLER_79_537 VPWR VGND sg13g2_decap_8
XFILLER_3_279 VPWR VGND sg13g2_decap_8
XFILLER_120_144 VPWR VGND sg13g2_fill_2
XFILLER_120_177 VPWR VGND sg13g2_fill_2
XFILLER_120_166 VPWR VGND sg13g2_fill_2
XFILLER_75_710 VPWR VGND sg13g2_decap_8
XFILLER_19_82 VPWR VGND sg13g2_fill_1
XFILLER_90_713 VPWR VGND sg13g2_decap_8
XFILLER_75_787 VPWR VGND sg13g2_fill_2
XFILLER_74_253 VPWR VGND sg13g2_decap_8
XFILLER_19_158 VPWR VGND sg13g2_decap_8
XFILLER_43_640 VPWR VGND sg13g2_fill_2
XFILLER_70_470 VPWR VGND sg13g2_fill_2
XFILLER_89_7 VPWR VGND sg13g2_decap_8
X_9473__2907 _9473_/RESET_B VPWR VGND sg13g2_tiehi
XFILLER_15_397 VPWR VGND sg13g2_fill_1
XFILLER_42_194 VPWR VGND sg13g2_decap_8
XFILLER_11_570 VPWR VGND sg13g2_decap_4
XFILLER_116_417 VPWR VGND sg13g2_decap_8
XFILLER_112_612 VPWR VGND sg13g2_decap_8
X_5100_ _5119_/A _5132_/D _5100_/B VPWR VGND sg13g2_nor2_1
X_6080_ _6080_/Y _6410_/C _6080_/B _6080_/C VPWR VGND sg13g2_nor3_1
XFILLER_111_144 VPWR VGND sg13g2_decap_4
XFILLER_97_345 VPWR VGND sg13g2_decap_8
X_5031_ _8540_/A _5029_/Y _5030_/Y _8520_/C VPWR VGND sg13g2_o21ai_1
XFILLER_85_507 VPWR VGND sg13g2_decap_8
XFILLER_112_689 VPWR VGND sg13g2_decap_8
XFILLER_97_389 VPWR VGND sg13g2_decap_8
XFILLER_78_581 VPWR VGND sg13g2_fill_1
XFILLER_38_423 VPWR VGND sg13g2_decap_8
XFILLER_26_618 VPWR VGND sg13g2_fill_1
X_6982_ _7793_/S _6982_/A _9258_/Q _8743_/D VPWR VGND sg13g2_nor3_1
X_8721_ _8721_/Q _9672_/CLK _8721_/D place2442/X VPWR VGND sg13g2_dfrbpq_1
XFILLER_65_297 VPWR VGND sg13g2_fill_2
XFILLER_53_448 VPWR VGND sg13g2_fill_1
X_5933_ _5933_/Y _5933_/A _5933_/B _5933_/C VPWR VGND sg13g2_nand3_1
X_5864_ _5864_/Y _5837_/A2 _9475_/Q VPWR VGND sg13g2_nand2b_1
X_8652_ _8652_/Q _9645_/CLK _8652_/D fanout970/X VPWR VGND sg13g2_dfrbpq_1
XFILLER_34_673 VPWR VGND sg13g2_decap_8
XFILLER_34_695 VPWR VGND sg13g2_decap_8
X_8583_ _8584_/A _9284_/Q _8585_/A2 _8585_/B1 _9481_/Q VPWR VGND sg13g2_a22oi_1
X_7603_ _7606_/C _9163_/Q _7725_/B VPWR VGND sg13g2_nor2_1
X_4815_ _4816_/D _4928_/B _4814_/Y _4959_/C VPWR VGND sg13g2_a21oi_1
XFILLER_119_200 VPWR VGND sg13g2_fill_2
X_5795_ _9290_/D _5795_/A VPWR VGND sg13g2_inv_1
X_7534_ _7534_/Y _7534_/A _7534_/B _7534_/C _7534_/D VPWR VGND sg13g2_nand4_1
X_4746_ _4750_/A _4880_/D _4903_/B VPWR VGND sg13g2_nand2_1
XFILLER_31_39 VPWR VGND sg13g2_decap_4
X_4677_ _4682_/A _9657_/Q _8719_/Q _9660_/Q VPWR VGND sg13g2_a21oi_1
Xplace2420 place2420/X place2421/X VPWR VGND sg13g2_buf_1
Xplace2431 place2431/X place2432/X VPWR VGND sg13g2_buf_1
X_7465_ _7466_/C _7469_/A _7819_/B _9094_/Q VPWR VGND sg13g2_nor3_1
XFILLER_103_9 VPWR VGND sg13g2_fill_1
Xplace2442 place2442/X place2450/X VPWR VGND sg13g2_buf_1
Xplace2453 place2453/X place2454/X VPWR VGND sg13g2_buf_1
X_7396_ _7396_/Y _7395_/X _7390_/Y _7459_/A VPWR VGND sg13g2_a21oi_1
X_9204_ _9204_/Q clkload7/A _9204_/D place2458/X VPWR VGND sg13g2_dfrbpq_1
X_6416_ _9390_/D _6279_/A _6414_/Y _6415_/Y VPWR VGND sg13g2_a21oi_1
Xplace2464 place2464/X place2476/X VPWR VGND sg13g2_buf_1
X_6347_ _9377_/D _6347_/A _6347_/B _6347_/C VPWR VGND sg13g2_nand3_1
Xplace2497 place2497/X place2498/X VPWR VGND sg13g2_buf_1
Xplace2486 place2486/X place2487/X VPWR VGND sg13g2_buf_1
Xplace2475 place2475/X place2476/X VPWR VGND sg13g2_buf_1
X_9135_ _9135_/Q _9501_/CLK _9135_/D place2464/X VPWR VGND sg13g2_dfrbpq_1
XFILLER_115_494 VPWR VGND sg13g2_decap_8
Xhold3133 _8323_/A _9162_/Q VPWR VGND sg13g2_dlygate4sd3_1
Xplace1774 _6663_/A1 _6569_/Y VPWR VGND sg13g2_buf_1
Xhold3122 _6788_/A1 _9546_/Q VPWR VGND sg13g2_dlygate4sd3_1
Xplace1796 _5315_/B _5254_/C VPWR VGND sg13g2_buf_1
Xplace1785 _8287_/B _8285_/B VPWR VGND sg13g2_buf_1
Xhold3100 _8241_/A _9121_/Q VPWR VGND sg13g2_dlygate4sd3_1
Xhold3111 _8187_/A _9094_/Q VPWR VGND sg13g2_dlygate4sd3_1
Xhold3155 _7026_/A _8830_/Q VPWR VGND sg13g2_dlygate4sd3_1
X_6278_ _6279_/C _8857_/Q _6962_/D _6277_/X _6430_/B2 VPWR VGND sg13g2_a22oi_1
Xhold3166 _5677_/B2 _8592_/Q VPWR VGND sg13g2_dlygate4sd3_1
X_9066_ _9066_/Q clkload8/A _9066_/D place2468/X VPWR VGND sg13g2_dfrbpq_1
Xhold3144 _8349_/A _9175_/Q VPWR VGND sg13g2_dlygate4sd3_1
XFILLER_76_529 VPWR VGND sg13g2_fill_2
Xhold3199 _8005_/B _9013_/Q VPWR VGND sg13g2_dlygate4sd3_1
X_5229_ _5233_/A _5272_/A _5243_/B _5260_/C VPWR VGND sg13g2_nand3_1
XFILLER_57_710 VPWR VGND sg13g2_fill_1
Xhold3177 _5697_/B2 _8602_/Q VPWR VGND sg13g2_dlygate4sd3_1
Xhold3188 _8135_/A _9068_/Q VPWR VGND sg13g2_dlygate4sd3_1
X_8017_ _8017_/Y _8017_/A _9019_/Q _8409_/C VPWR VGND sg13g2_nand3_1
Xdelaybuf_2_clk_jtg delaybuf_3_clk_jtg/A delaybuf_2_clk_jtg/A VPWR VGND sg13g2_buf_8
XFILLER_84_573 VPWR VGND sg13g2_fill_2
XFILLER_56_58 VPWR VGND sg13g2_decap_8
XFILLER_29_467 VPWR VGND sg13g2_fill_1
XFILLER_72_724 VPWR VGND sg13g2_fill_2
XFILLER_71_223 VPWR VGND sg13g2_fill_2
XFILLER_16_128 VPWR VGND sg13g2_decap_8
X_8919_ _8919_/Q _9615_/CLK _8919_/D place2418/X VPWR VGND sg13g2_dfrbpq_1
X_9592__2798 _9592_/RESET_B VPWR VGND sg13g2_tiehi
XFILLER_12_378 VPWR VGND sg13g2_decap_8
XFILLER_115_0 VPWR VGND sg13g2_decap_8
XFILLER_113_409 VPWR VGND sg13g2_decap_8
XFILLER_79_367 VPWR VGND sg13g2_decap_4
X_9527__2853 _9527_/RESET_B VPWR VGND sg13g2_tiehi
XFILLER_75_573 VPWR VGND sg13g2_decap_8
XFILLER_47_253 VPWR VGND sg13g2_fill_1
XFILLER_75_584 VPWR VGND sg13g2_decap_8
XFILLER_62_212 VPWR VGND sg13g2_decap_4
XFILLER_90_565 VPWR VGND sg13g2_fill_1
XFILLER_35_448 VPWR VGND sg13g2_decap_8
XFILLER_50_429 VPWR VGND sg13g2_decap_8
XFILLER_16_695 VPWR VGND sg13g2_fill_2
XFILLER_31_643 VPWR VGND sg13g2_decap_4
X_4600_ _4606_/D _9208_/Q _9670_/Q _9673_/Q _9672_/Q VPWR VGND sg13g2_nor4_1
Xclkbuf_leaf_19_clk_i _9219_/CLK clkbuf_3_6__f_clk_i/X VPWR VGND sg13g2_buf_16
XFILLER_31_687 VPWR VGND sg13g2_fill_1
X_5580_ _5580_/Y _8649_/Q _5592_/A2 _5580_/B1 _8648_/Q VPWR VGND sg13g2_a22oi_1
XFILLER_117_704 VPWR VGND sg13g2_fill_1
X_4531_ _5403_/B _7704_/A _7705_/A _7705_/B _7269_/A VPWR VGND sg13g2_nand4_1
XFILLER_7_63 VPWR VGND sg13g2_fill_2
XFILLER_116_236 VPWR VGND sg13g2_decap_8
X_7250_ _7253_/B _7278_/C _7297_/B _8959_/Q VPWR VGND sg13g2_nor3_1
X_4462_ _6544_/A _4462_/A _9693_/Q VPWR VGND sg13g2_nand2_1
XFILLER_104_409 VPWR VGND sg13g2_decap_8
X_6201_ _9358_/D _6200_/Y _9358_/Q _6253_/S VPWR VGND sg13g2_mux2_1
XFILLER_98_610 VPWR VGND sg13g2_fill_1
Xfanout807 _8817_/D slave_addr_i[2] VPWR VGND sg13g2_buf_1
X_4393_ _4394_/A _5439_/A1 _8675_/Q _8676_/Q _5469_/B2 VPWR VGND sg13g2_a22oi_1
X_7181_ _8878_/D _7180_/Y _8878_/Q _7185_/S VPWR VGND sg13g2_mux2_1
XFILLER_112_431 VPWR VGND sg13g2_decap_8
XFILLER_97_131 VPWR VGND sg13g2_fill_2
X_6132_ _9350_/D _6132_/A _6131_/Y VPWR VGND sg13g2_nor2b_1
XFILLER_30_0 VPWR VGND sg13g2_decap_8
XFILLER_58_518 VPWR VGND sg13g2_fill_1
X_6063_ _6063_/X _8959_/Q _9021_/Q _9083_/Q _9145_/Q _6381_/S0 _6363_/S1 VPWR VGND
+ sg13g2_mux4_1
X_5014_ _5014_/Y _4957_/D _5011_/Y _5013_/Y VPWR VGND sg13g2_o21ai_1
XFILLER_81_521 VPWR VGND sg13g2_fill_2
X_6965_ _7131_/S _7218_/B _6962_/Y _6964_/Y VPWR VGND sg13g2_o21ai_1
X_5916_ _5917_/B _5954_/A _5932_/B _5989_/A _5924_/D VPWR VGND sg13g2_nand4_1
X_8704_ _8704_/Q _9675_/CLK _8704_/D place2449/X VPWR VGND sg13g2_dfrbpq_1
X_9684_ _9684_/Q _9689_/CLK _9684_/D fanout963/X VPWR VGND sg13g2_dfrbpq_1
X_6896_ _9614_/D _6895_/X _9614_/Q _6910_/S VPWR VGND sg13g2_mux2_1
X_8635_ _8635_/Q _9645_/CLK _8635_/D fanout981/X VPWR VGND sg13g2_dfrbpq_1
XFILLER_34_492 VPWR VGND sg13g2_fill_2
X_5847_ _9307_/D _9307_/Q _5920_/B _5846_/Y VPWR VGND sg13g2_a21o_1
XFILLER_42_49 VPWR VGND sg13g2_decap_8
X_5778_ _5778_/X _9319_/Q _9335_/Q _9311_/Q _9327_/Q _5938_/A _5843_/A2 VPWR VGND
+ sg13g2_mux4_1
X_8566_ _9275_/D _5840_/Y _8563_/X _8565_/Y VPWR VGND sg13g2_o21ai_1
X_7517_ _7517_/Y _7513_/Y _7516_/Y _5377_/X VPWR VGND sg13g2_a21oi_1
X_8497_ _9253_/D _8496_/A _5345_/C _8496_/Y VPWR VGND sg13g2_o21ai_1
XFILLER_5_319 VPWR VGND sg13g2_fill_1
X_4729_ _9685_/D _4729_/A _4729_/B VPWR VGND sg13g2_nor2_1
X_7448_ _7448_/Y _7448_/A _7448_/B _7448_/C _7448_/D VPWR VGND sg13g2_nor4_1
X_9577__2813 _9577_/RESET_B VPWR VGND sg13g2_tiehi
Xplace2250 _7839_/C _7820_/A VPWR VGND sg13g2_buf_1
Xplace2272 _7297_/B _7492_/B VPWR VGND sg13g2_buf_1
Xplace2261 _7820_/A _9465_/Q VPWR VGND sg13g2_buf_1
XFILLER_116_770 VPWR VGND sg13g2_decap_8
X_7379_ _8902_/D _8902_/Q _7378_/Y _7848_/S VPWR VGND sg13g2_mux2_1
Xplace2283 _4816_/A _4903_/A VPWR VGND sg13g2_buf_1
Xplace2294 _4844_/B _4823_/B VPWR VGND sg13g2_buf_1
XFILLER_115_280 VPWR VGND sg13g2_fill_1
XFILLER_107_75 VPWR VGND sg13g2_decap_4
X_9118_ _9118_/Q _9183_/CLK _9118_/D place2497/X VPWR VGND sg13g2_dfrbpq_1
X_9049_ _9049_/Q _9199_/CLK _9049_/D place2427/X VPWR VGND sg13g2_dfrbpq_1
XFILLER_76_359 VPWR VGND sg13g2_decap_8
XFILLER_57_551 VPWR VGND sg13g2_decap_4
XFILLER_45_713 VPWR VGND sg13g2_decap_8
XFILLER_123_63 VPWR VGND sg13g2_decap_8
XFILLER_72_521 VPWR VGND sg13g2_fill_1
XFILLER_72_510 VPWR VGND sg13g2_decap_4
XFILLER_29_275 VPWR VGND sg13g2_decap_8
XFILLER_45_768 VPWR VGND sg13g2_fill_2
XFILLER_72_598 VPWR VGND sg13g2_decap_8
XFILLER_60_716 VPWR VGND sg13g2_decap_8
XFILLER_9_614 VPWR VGND sg13g2_decap_8
XFILLER_13_654 VPWR VGND sg13g2_decap_4
XFILLER_8_168 VPWR VGND sg13g2_decap_8
XFILLER_121_250 VPWR VGND sg13g2_decap_4
XFILLER_0_580 VPWR VGND sg13g2_decap_8
XFILLER_94_145 VPWR VGND sg13g2_fill_2
XFILLER_67_359 VPWR VGND sg13g2_fill_1
XFILLER_90_384 VPWR VGND sg13g2_decap_4
XFILLER_90_373 VPWR VGND sg13g2_decap_4
XFILLER_63_576 VPWR VGND sg13g2_fill_1
XFILLER_50_215 VPWR VGND sg13g2_decap_4
X_6750_ _9509_/D _9509_/Q _9419_/Q _6756_/S VPWR VGND sg13g2_mux2_1
XFILLER_23_429 VPWR VGND sg13g2_fill_2
X_5701_ _5702_/B _9664_/Q _9665_/Q VPWR VGND sg13g2_or2_1
XFILLER_16_470 VPWR VGND sg13g2_decap_8
X_6681_ _9457_/D _9459_/Q _4649_/X _6680_/Y VPWR VGND sg13g2_o21ai_1
XFILLER_31_451 VPWR VGND sg13g2_decap_8
XFILLER_31_462 VPWR VGND sg13g2_fill_2
X_8420_ _8420_/Y _8432_/A _9214_/Q _8430_/C VPWR VGND sg13g2_nand3_1
XFILLER_31_473 VPWR VGND sg13g2_decap_8
X_5632_ _5633_/A _8620_/Q _5699_/A2 _5699_/B1 _5632_/B2 VPWR VGND sg13g2_a22oi_1
X_5563_ _8642_/D _5562_/Y _5561_/Y _5581_/B1 VPWR VGND sg13g2_a21oi_1
XFILLER_78_0 VPWR VGND sg13g2_decap_4
X_8351_ _8351_/Y _8355_/A _9176_/Q _8353_/C VPWR VGND sg13g2_nand3_1
X_4514_ _8092_/C _6982_/A _9690_/Q _8743_/D _7004_/A VPWR VGND sg13g2_nor4_1
X_7302_ _7304_/D _9860_/A _7825_/A2 _7825_/B1 _7302_/B2 VPWR VGND sg13g2_a22oi_1
X_8282_ _9141_/D _8563_/D _8095_/Y _8281_/Y VPWR VGND sg13g2_o21ai_1
X_5494_ _5494_/X _5494_/A _5494_/B VPWR VGND sg13g2_and2_1
X_7233_ _7233_/Y _7237_/A1 _9500_/Q _7237_/B1 _7237_/B2 VPWR VGND sg13g2_a22oi_1
X_4445_ _4446_/B _7218_/A _7214_/B _7224_/B _7221_/A VPWR VGND sg13g2_nor4_1
XFILLER_113_740 VPWR VGND sg13g2_decap_4
X_4376_ _6743_/C _9642_/Q _4376_/B VPWR VGND sg13g2_nand2_1
X_7164_ _8873_/D _7163_/Y _8873_/Q _7185_/S VPWR VGND sg13g2_mux2_1
X_6115_ _6410_/D _6103_/B _6369_/B _6397_/B VPWR VGND sg13g2_a21oi_1
XFILLER_100_412 VPWR VGND sg13g2_fill_1
XFILLER_85_134 VPWR VGND sg13g2_decap_8
XFILLER_58_337 VPWR VGND sg13g2_decap_8
X_7095_ _8851_/D _7094_/Y _8851_/Q _7110_/S VPWR VGND sg13g2_mux2_1
X_6046_ _6046_/Y _6046_/A _6071_/B _8817_/D _6046_/D VPWR VGND sg13g2_nand4_1
XFILLER_54_532 VPWR VGND sg13g2_decap_4
X_7997_ _7997_/Y _8011_/A _9009_/Q _8389_/C VPWR VGND sg13g2_nand3_1
XFILLER_54_576 VPWR VGND sg13g2_fill_1
XFILLER_26_278 VPWR VGND sg13g2_decap_8
X_6948_ _6948_/Y _6952_/S _6948_/B VPWR VGND sg13g2_nand2b_1
X_6879_ _6879_/X _8913_/Q _8945_/Q _6909_/S VPWR VGND sg13g2_mux2_1
X_9667_ _9667_/Q _9672_/CLK _9667_/D place2441/X VPWR VGND sg13g2_dfrbpq_1
XFILLER_41_259 VPWR VGND sg13g2_fill_2
X_9598_ _9598_/Q _9603_/CLK _9598_/D _9598_/RESET_B VPWR VGND sg13g2_dfrbpq_1
XFILLER_50_782 VPWR VGND sg13g2_fill_2
X_8618_ _8618_/Q _9701_/CLK _8618_/D fanout960/X VPWR VGND sg13g2_dfrbpq_1
X_8549_ _9267_/D _8549_/A VPWR VGND sg13g2_inv_1
XFILLER_108_523 VPWR VGND sg13g2_fill_1
XFILLER_108_512 VPWR VGND sg13g2_decap_8
XFILLER_118_30 VPWR VGND sg13g2_fill_1
XFILLER_108_556 VPWR VGND sg13g2_decap_4
Xplace2080 _5891_/B2 _5952_/A VPWR VGND sg13g2_buf_1
Xplace2091 _5843_/A2 _5085_/Y VPWR VGND sg13g2_buf_1
XFILLER_1_300 VPWR VGND sg13g2_decap_4
XFILLER_89_495 VPWR VGND sg13g2_decap_8
XFILLER_77_657 VPWR VGND sg13g2_fill_1
XFILLER_1_399 VPWR VGND sg13g2_decap_4
XFILLER_76_167 VPWR VGND sg13g2_decap_4
XFILLER_64_307 VPWR VGND sg13g2_decap_8
XFILLER_49_359 VPWR VGND sg13g2_decap_8
XFILLER_91_115 VPWR VGND sg13g2_fill_2
XFILLER_72_373 VPWR VGND sg13g2_decap_8
XFILLER_17_256 VPWR VGND sg13g2_decap_8
XFILLER_32_204 VPWR VGND sg13g2_fill_1
XFILLER_32_237 VPWR VGND sg13g2_fill_1
XFILLER_33_749 VPWR VGND sg13g2_decap_8
XFILLER_60_579 VPWR VGND sg13g2_fill_1
XFILLER_43_81 VPWR VGND sg13g2_decap_8
XFILLER_9_466 VPWR VGND sg13g2_fill_1
XFILLER_99_259 VPWR VGND sg13g2_fill_1
XFILLER_4_42 VPWR VGND sg13g2_decap_8
XFILLER_95_421 VPWR VGND sg13g2_fill_1
XFILLER_95_454 VPWR VGND sg13g2_fill_1
XFILLER_55_318 VPWR VGND sg13g2_fill_1
X_7920_ _7920_/Y _8086_/A _9485_/Q _8095_/C _8086_/D VPWR VGND sg13g2_nand4_1
X_7851_ _8928_/D _8928_/Q _7267_/Y _7884_/S VPWR VGND sg13g2_mux2_1
XFILLER_91_671 VPWR VGND sg13g2_decap_4
X_6802_ _9554_/D _9554_/Q _9548_/Q _6802_/S VPWR VGND sg13g2_mux2_1
XFILLER_63_351 VPWR VGND sg13g2_fill_1
X_7782_ _7785_/C _9048_/Q _7782_/B VPWR VGND sg13g2_nor2_1
X_4994_ _4997_/A _4994_/A _9372_/Q VPWR VGND sg13g2_nor2b_1
XFILLER_23_226 VPWR VGND sg13g2_fill_1
X_9521_ _9521_/Q _9567_/CLK _9521_/D _9521_/RESET_B VPWR VGND sg13g2_dfrbpq_1
X_6733_ _9501_/D _9542_/Q _9501_/Q _6733_/S VPWR VGND sg13g2_mux2_1
X_6664_ _6664_/Y _9451_/Q _6671_/B VPWR VGND sg13g2_nand2_1
X_9452_ _9452_/Q _9587_/CLK _9452_/D fanout979/X VPWR VGND sg13g2_dfrbpq_1
X_8403_ _8403_/Y _8403_/A _9202_/Q _8403_/C VPWR VGND sg13g2_nand3_1
X_5615_ _5615_/Y _5615_/A _5615_/B VPWR VGND sg13g2_nand2_1
X_6595_ _6595_/Y _6661_/C _8632_/Q _9564_/Q _6669_/B2 VPWR VGND sg13g2_a22oi_1
X_9383_ _9383_/Q clkload9/A _9383_/D place2504/X VPWR VGND sg13g2_dfrbpq_1
X_5546_ _5546_/Y _5585_/A _5585_/B _8638_/Q _5585_/D VPWR VGND sg13g2_nand4_1
X_8334_ _9167_/D _8346_/A1 _8080_/Y _8333_/Y VPWR VGND sg13g2_o21ai_1
XFILLER_117_375 VPWR VGND sg13g2_decap_8
X_8265_ _8265_/Y _8265_/A _8279_/B VPWR VGND sg13g2_nand2_1
X_5477_ _6945_/A _6566_/A _6948_/B VPWR VGND sg13g2_nor2_1
X_7216_ _7216_/Y _7238_/A1 _7214_/Y _7215_/Y VPWR VGND sg13g2_a21oi_1
X_4428_ _5391_/B _6369_/A _6153_/D VPWR VGND sg13g2_nand2_1
X_8196_ _9098_/D _8226_/A1 _8061_/Y _8195_/Y VPWR VGND sg13g2_o21ai_1
XFILLER_113_592 VPWR VGND sg13g2_decap_8
XFILLER_98_281 VPWR VGND sg13g2_fill_2
X_7147_ _7147_/Y _7156_/A _8868_/Q VPWR VGND sg13g2_nand2_1
X_4359_ _4359_/Y _8734_/Q _9681_/Q VPWR VGND sg13g2_nand2b_1
XFILLER_59_679 VPWR VGND sg13g2_fill_2
XFILLER_58_145 VPWR VGND sg13g2_decap_8
XFILLER_58_134 VPWR VGND sg13g2_fill_2
XFILLER_47_808 VPWR VGND sg13g2_fill_1
X_7078_ _7078_/Y _5357_/C _7100_/A2 _7077_/Y VPWR VGND sg13g2_o21ai_1
XFILLER_86_487 VPWR VGND sg13g2_decap_8
XFILLER_86_476 VPWR VGND sg13g2_fill_1
X_6029_ _6161_/A _6035_/A _6399_/A VPWR VGND sg13g2_or2_1
XFILLER_104_87 VPWR VGND sg13g2_decap_8
XFILLER_104_98 VPWR VGND sg13g2_fill_1
XFILLER_64_58 VPWR VGND sg13g2_decap_8
XFILLER_54_384 VPWR VGND sg13g2_decap_8
XFILLER_120_42 VPWR VGND sg13g2_decap_8
XFILLER_22_270 VPWR VGND sg13g2_decap_8
XFILLER_10_498 VPWR VGND sg13g2_decap_8
XFILLER_108_375 VPWR VGND sg13g2_decap_8
XFILLER_8_0 VPWR VGND sg13g2_decap_8
XFILLER_123_378 VPWR VGND sg13g2_decap_8
XFILLER_77_465 VPWR VGND sg13g2_decap_8
XFILLER_49_134 VPWR VGND sg13g2_decap_8
XFILLER_92_402 VPWR VGND sg13g2_fill_2
XFILLER_77_476 VPWR VGND sg13g2_decap_8
XFILLER_64_137 VPWR VGND sg13g2_decap_8
XFILLER_18_532 VPWR VGND sg13g2_fill_2
XFILLER_33_513 VPWR VGND sg13g2_decap_8
XFILLER_73_693 VPWR VGND sg13g2_decap_8
XFILLER_33_557 VPWR VGND sg13g2_decap_8
XFILLER_9_252 VPWR VGND sg13g2_decap_8
XFILLER_118_139 VPWR VGND sg13g2_decap_8
Xclkload22 clkload22/X _9260_/CLK VPWR VGND sg13g2_buf_8
Xclkload33 clkload33/Y _9587_/CLK VPWR VGND sg13g2_inv_1
X_5400_ _5404_/C _5400_/A _5400_/B _5400_/C VPWR VGND sg13g2_nand3_1
Xclkload11 clkload11/Y _9242_/CLK VPWR VGND sg13g2_inv_1
X_6380_ _9383_/D _6056_/Y _6378_/Y _6379_/Y VPWR VGND sg13g2_a21oi_1
X_5331_ _8781_/D _5341_/A1 _5373_/C _5330_/Y _5336_/B2 VPWR VGND sg13g2_a22oi_1
X_8050_ _8050_/Y _8056_/A _9482_/Q _8056_/C _8056_/D VPWR VGND sg13g2_nand4_1
X_7001_ _8823_/D _8823_/Q _7000_/Y _7830_/S VPWR VGND sg13g2_mux2_1
X_5262_ _5262_/Y _9877_/A _5254_/Y _5261_/Y VPWR VGND sg13g2_o21ai_1
X_5193_ _5254_/C _5192_/C _5190_/B _5191_/Y _5138_/Y VPWR VGND sg13g2_a22oi_1
XFILLER_110_540 VPWR VGND sg13g2_fill_2
XFILLER_68_465 VPWR VGND sg13g2_fill_1
X_8952_ _8952_/Q _9615_/CLK _8952_/D place2417/X VPWR VGND sg13g2_dfrbpq_1
XFILLER_83_446 VPWR VGND sg13g2_decap_8
X_8883_ _8883_/Q _9252_/CLK _8883_/D place2426/X VPWR VGND sg13g2_dfrbpq_1
X_7903_ _8965_/D _5350_/C _7904_/A _7901_/Y VPWR VGND sg13g2_o21ai_1
XFILLER_36_351 VPWR VGND sg13g2_decap_8
XFILLER_36_362 VPWR VGND sg13g2_decap_8
XFILLER_64_682 VPWR VGND sg13g2_decap_8
XFILLER_24_513 VPWR VGND sg13g2_decap_8
X_7834_ _7836_/C _7834_/A _7834_/B _9113_/Q VPWR VGND sg13g2_nor3_1
X_7765_ _7768_/A _7803_/A _7799_/B _9109_/Q VPWR VGND sg13g2_nor3_1
X_6716_ _9484_/D _9525_/Q _9484_/Q _6729_/S VPWR VGND sg13g2_mux2_1
X_9504_ _9504_/Q _9504_/CLK _9504_/D _9504_/RESET_B VPWR VGND sg13g2_dfrbpq_1
XFILLER_11_207 VPWR VGND sg13g2_fill_1
X_4977_ _4977_/Y _4977_/A _4977_/B VPWR VGND sg13g2_nor2_1
X_7696_ _7696_/Y _7696_/A _7696_/B _7696_/C _7696_/D VPWR VGND sg13g2_nand4_1
Xclkload5 clkload5/X clkload5/A VPWR VGND sg13g2_buf_8
X_6647_ _9445_/D _6653_/A1 _6646_/Y _6645_/Y VPWR VGND sg13g2_o21ai_1
X_9435_ _9435_/Q _9567_/CLK _9435_/D fanout980/X VPWR VGND sg13g2_dfrbpq_1
XFILLER_119_7 VPWR VGND sg13g2_decap_8
X_6578_ _6578_/Y _6588_/C _8627_/Q _9559_/Q _6566_/Y VPWR VGND sg13g2_a22oi_1
X_9366_ _9366_/Q clkload9/A _9366_/D place2493/X VPWR VGND sg13g2_dfrbpq_1
X_5529_ _5529_/Y _9429_/Q _5600_/B _5601_/B1 _8631_/Q VPWR VGND sg13g2_a22oi_1
X_8317_ _8317_/Y _8317_/A _8347_/B VPWR VGND sg13g2_nand2_1
X_9297_ _9297_/Q _9305_/CLK _9297_/D place2395/X VPWR VGND sg13g2_dfrbpq_1
Xoutput2681 master_addr_o[28] _9886_/X VPWR VGND sg13g2_buf_1
Xoutput2670 master_addr_o[18] _9876_/X VPWR VGND sg13g2_buf_1
Xoutput2692 master_addr_o[9] _9867_/X VPWR VGND sg13g2_buf_1
XFILLER_1_7 VPWR VGND sg13g2_decap_8
X_8248_ _9124_/D _8252_/A1 _8047_/Y _8247_/Y VPWR VGND sg13g2_o21ai_1
XFILLER_87_730 VPWR VGND sg13g2_decap_4
X_8179_ _8179_/Y _9090_/Q _8197_/B VPWR VGND sg13g2_nand2_1
XFILLER_87_796 VPWR VGND sg13g2_fill_2
XFILLER_59_487 VPWR VGND sg13g2_decap_8
XFILLER_55_660 VPWR VGND sg13g2_decap_4
XFILLER_43_800 VPWR VGND sg13g2_fill_1
XFILLER_61_118 VPWR VGND sg13g2_decap_4
XFILLER_54_181 VPWR VGND sg13g2_fill_2
XFILLER_54_170 VPWR VGND sg13g2_decap_8
XFILLER_70_685 VPWR VGND sg13g2_decap_8
XFILLER_30_538 VPWR VGND sg13g2_decap_4
XFILLER_11_774 VPWR VGND sg13g2_fill_2
XFILLER_7_745 VPWR VGND sg13g2_decap_8
XFILLER_123_175 VPWR VGND sg13g2_fill_1
XFILLER_77_273 VPWR VGND sg13g2_decap_4
XFILLER_1_21 VPWR VGND sg13g2_decap_8
XFILLER_93_755 VPWR VGND sg13g2_decap_4
XFILLER_65_435 VPWR VGND sg13g2_decap_8
XFILLER_37_137 VPWR VGND sg13g2_decap_4
XFILLER_92_276 VPWR VGND sg13g2_fill_1
X_5880_ _5880_/Y _5781_/A _9477_/Q VPWR VGND sg13g2_nand2b_1
XFILLER_92_298 VPWR VGND sg13g2_fill_1
XFILLER_73_490 VPWR VGND sg13g2_decap_8
X_4900_ _4900_/Y _9390_/Q _4979_/A2 _4899_/Y _4844_/B _4896_/Y VPWR VGND sg13g2_a221oi_1
X_4831_ _4831_/Y _4831_/A _4831_/B VPWR VGND sg13g2_nor2_1
XFILLER_45_192 VPWR VGND sg13g2_decap_8
XFILLER_61_696 VPWR VGND sg13g2_decap_8
XFILLER_33_365 VPWR VGND sg13g2_fill_2
X_7550_ _7550_/X _9873_/A _7694_/B VPWR VGND sg13g2_and2_1
XFILLER_60_195 VPWR VGND sg13g2_decap_8
XFILLER_60_184 VPWR VGND sg13g2_fill_1
XFILLER_21_549 VPWR VGND sg13g2_decap_8
X_4762_ _4959_/C _4793_/B _4924_/A _4925_/A2 VPWR VGND sg13g2_o21ai_1
X_4693_ _6795_/S _4694_/A _4693_/B _4693_/C VPWR VGND sg13g2_nor3_1
X_7481_ _7484_/B _8796_/Q _7660_/A2 _7809_/B1 _7481_/B2 VPWR VGND sg13g2_a22oi_1
X_6501_ _6501_/Y _6499_/Y _6500_/Y _6455_/A VPWR VGND sg13g2_a21oi_1
X_9220_ _9220_/Q _9304_/CLK _9220_/D place2421/X VPWR VGND sg13g2_dfrbpq_1
X_6432_ _9394_/D _9394_/Q _6431_/Y _6432_/S VPWR VGND sg13g2_mux2_1
XFILLER_60_0 VPWR VGND sg13g2_decap_8
X_9151_ _9151_/Q _9183_/CLK _9151_/D place2472/X VPWR VGND sg13g2_dfrbpq_1
Xplace1912 _8039_/A _7010_/A VPWR VGND sg13g2_buf_1
Xplace1901 _6328_/C _6055_/A VPWR VGND sg13g2_buf_1
XFILLER_115_632 VPWR VGND sg13g2_decap_8
XFILLER_115_621 VPWR VGND sg13g2_fill_2
Xplace1934 _7811_/C _7004_/C VPWR VGND sg13g2_buf_1
Xplace1945 _7598_/A2 _7788_/B1 VPWR VGND sg13g2_buf_1
X_6363_ _6363_/X _8995_/Q _9057_/Q _9119_/Q _9181_/Q _6381_/S0 _6363_/S1 VPWR VGND
+ sg13g2_mux4_1
Xplace1923 _7207_/C _7036_/C VPWR VGND sg13g2_buf_1
X_8102_ _9051_/D _8102_/A1 _7957_/Y _8101_/Y VPWR VGND sg13g2_o21ai_1
XFILLER_114_142 VPWR VGND sg13g2_fill_1
Xplace1967 _7557_/B1 _7796_/B1 VPWR VGND sg13g2_buf_1
Xplace1978 _8284_/A1 _8563_/D VPWR VGND sg13g2_buf_1
X_5314_ _5315_/A _9884_/A _9885_/A _5329_/B _5314_/D VPWR VGND sg13g2_nand4_1
Xplace1956 _6422_/B1 _6401_/B2 VPWR VGND sg13g2_buf_1
X_6294_ _6294_/Y _8859_/Q _6496_/A2 _6293_/X _6430_/B2 _6275_/B VPWR VGND sg13g2_a221oi_1
X_9082_ _9082_/Q _9501_/CLK _9082_/D place2468/X VPWR VGND sg13g2_dfrbpq_1
Xplace1989 _7808_/B1 _7787_/B VPWR VGND sg13g2_buf_1
X_5245_ _8768_/D _5274_/A1 _5360_/C _5244_/Y _5274_/B2 VPWR VGND sg13g2_a22oi_1
X_8033_ _8033_/Y _8033_/A _8052_/B VPWR VGND sg13g2_nand2_1
XFILLER_96_560 VPWR VGND sg13g2_decap_4
X_5176_ _5192_/C _9865_/A _5176_/B VPWR VGND sg13g2_nand2b_1
XFILLER_68_262 VPWR VGND sg13g2_decap_4
X_8935_ _8935_/Q _9620_/CLK _8935_/D place2438/X VPWR VGND sg13g2_dfrbpq_1
XFILLER_71_405 VPWR VGND sg13g2_decap_4
X_8866_ _8866_/Q _9692_/CLK _8866_/D place2493/X VPWR VGND sg13g2_dfrbpq_1
X_8797_ _8797_/Q _9219_/CLK _8797_/D place2402/X VPWR VGND sg13g2_dfrbpq_1
X_7817_ _7817_/Y _7817_/A _7817_/B _7817_/C _7817_/D VPWR VGND sg13g2_nor4_1
X_7748_ _7749_/B _9201_/Q _7804_/B _7785_/A VPWR VGND sg13g2_o21ai_1
XFILLER_24_398 VPWR VGND sg13g2_fill_1
X_7679_ _7681_/A _8750_/Q _7520_/B _7788_/B1 _8855_/Q VPWR VGND sg13g2_a22oi_1
Xinput2557 _7737_/B2 hartinfo_i[25] VPWR VGND sg13g2_buf_1
Xinput2546 _7538_/B2 hartinfo_i[15] VPWR VGND sg13g2_buf_1
Xinput2568 _7373_/A hartinfo_i[6] VPWR VGND sg13g2_buf_1
Xinput2579 _5913_/A master_rdata_i[10] VPWR VGND sg13g2_buf_1
XFILLER_20_571 VPWR VGND sg13g2_fill_1
X_9418_ _9418_/Q _9511_/CLK _9418_/D fanout958/X VPWR VGND sg13g2_dfrbpq_1
XFILLER_117_4 VPWR VGND sg13g2_fill_1
X_9349_ _9349_/Q _9414_/CLK _9349_/D place2502/X VPWR VGND sg13g2_dfrbpq_1
XFILLER_3_203 VPWR VGND sg13g2_decap_4
XFILLER_106_654 VPWR VGND sg13g2_decap_8
XFILLER_3_258 VPWR VGND sg13g2_decap_8
XFILLER_87_582 VPWR VGND sg13g2_decap_8
XFILLER_74_221 VPWR VGND sg13g2_fill_2
XFILLER_47_446 VPWR VGND sg13g2_fill_2
XFILLER_19_137 VPWR VGND sg13g2_decap_8
XFILLER_28_671 VPWR VGND sg13g2_fill_1
XFILLER_90_769 VPWR VGND sg13g2_decap_8
XFILLER_35_60 VPWR VGND sg13g2_decap_4
XFILLER_43_685 VPWR VGND sg13g2_fill_1
XFILLER_43_696 VPWR VGND sg13g2_decap_8
XFILLER_7_564 VPWR VGND sg13g2_decap_4
XFILLER_109_470 VPWR VGND sg13g2_decap_8
XFILLER_97_302 VPWR VGND sg13g2_decap_8
XFILLER_112_668 VPWR VGND sg13g2_decap_8
XFILLER_97_357 VPWR VGND sg13g2_decap_8
X_5030_ _5030_/Y _5124_/A _5026_/Y _5028_/Y VPWR VGND sg13g2_o21ai_1
XFILLER_78_593 VPWR VGND sg13g2_fill_1
X_6981_ _8822_/D _6980_/Y _8822_/Q _7239_/S VPWR VGND sg13g2_mux2_1
XFILLER_53_405 VPWR VGND sg13g2_fill_2
X_5932_ _5933_/B _5945_/A _5932_/B _5995_/A _5932_/D VPWR VGND sg13g2_nand4_1
X_8720_ _8720_/Q _9672_/CLK _9555_/Q place2442/X VPWR VGND sg13g2_dfrbpq_1
XFILLER_65_276 VPWR VGND sg13g2_fill_1
XFILLER_34_630 VPWR VGND sg13g2_fill_1
X_5863_ _9309_/D _9309_/Q _5920_/B _5862_/Y VPWR VGND sg13g2_a21o_1
X_8651_ _8651_/Q _9649_/CLK _8651_/D fanout970/X VPWR VGND sg13g2_dfrbpq_1
XFILLER_61_471 VPWR VGND sg13g2_fill_2
XFILLER_33_162 VPWR VGND sg13g2_decap_4
X_8582_ _9283_/D _8582_/A VPWR VGND sg13g2_inv_1
X_5794_ _5795_/A _9290_/Q _8587_/A2 _8587_/B1 _9487_/Q VPWR VGND sg13g2_a22oi_1
XFILLER_61_493 VPWR VGND sg13g2_fill_1
X_7602_ _7606_/B _9194_/Q _7670_/B _7667_/A VPWR VGND sg13g2_o21ai_1
XFILLER_21_346 VPWR VGND sg13g2_fill_1
X_4814_ _4814_/Y _4823_/B _4814_/B VPWR VGND sg13g2_nor2_1
X_7533_ _7534_/A _8798_/Q _7301_/B _7533_/B1 _8878_/Q _7519_/X VPWR VGND sg13g2_a221oi_1
X_4745_ _4783_/C _4903_/A _4903_/B VPWR VGND sg13g2_nor2b_1
X_4676_ _9651_/D _8715_/Q _9651_/Q _6690_/S VPWR VGND sg13g2_a21o_1
Xplace2421 place2421/X place2422/X VPWR VGND sg13g2_buf_1
Xplace2410 place2410/X place2421/X VPWR VGND sg13g2_buf_1
X_7464_ _7466_/B _9156_/Q _7491_/B VPWR VGND sg13g2_nor2_1
Xplace2443 place2443/X place2450/X VPWR VGND sg13g2_buf_1
Xplace2432 place2432/X place2433/X VPWR VGND sg13g2_buf_1
X_7395_ _7395_/X _7395_/A _7395_/B _7395_/C _7395_/D VPWR VGND sg13g2_and4_1
Xplace2454 place2454/X place2488/X VPWR VGND sg13g2_buf_1
X_9203_ _9203_/Q clkload7/A _9203_/D place2458/X VPWR VGND sg13g2_dfrbpq_1
Xplace2465 place2465/X place2467/X VPWR VGND sg13g2_buf_1
X_6415_ _6415_/Y _6415_/A1 _6512_/A2 _6415_/B1 VPWR VGND sg13g2_a21oi_1
X_9134_ _9134_/Q clkload7/A _9134_/D place2457/X VPWR VGND sg13g2_dfrbpq_1
Xplace2487 place2487/X place2488/X VPWR VGND sg13g2_buf_1
X_6346_ _6347_/C _8865_/Q _6346_/B _6958_/C VPWR VGND sg13g2_nand3_1
Xplace2498 place2498/X place2499/X VPWR VGND sg13g2_buf_1
Xplace2476 place2476/X place2487/X VPWR VGND sg13g2_buf_1
XFILLER_115_473 VPWR VGND sg13g2_decap_8
Xplace1775 _6651_/B _6654_/B VPWR VGND sg13g2_buf_1
Xhold3112 _8265_/A _9133_/Q VPWR VGND sg13g2_dlygate4sd3_1
Xplace1797 _5242_/C _5254_/C VPWR VGND sg13g2_buf_1
Xhold3101 _8113_/A _9057_/Q VPWR VGND sg13g2_dlygate4sd3_1
Xplace1786 _8251_/B _8243_/B VPWR VGND sg13g2_buf_1
X_9065_ _9065_/Q _9188_/CLK _9065_/D place2475/X VPWR VGND sg13g2_dfrbpq_1
Xhold3123 _8305_/A _9153_/Q VPWR VGND sg13g2_dlygate4sd3_1
XFILLER_102_134 VPWR VGND sg13g2_decap_8
X_6277_ _6277_/X _8983_/Q _9045_/Q _9107_/Q _9169_/Q _6302_/S0 _6440_/S1 VPWR VGND
+ sg13g2_mux4_1
XFILLER_0_239 VPWR VGND sg13g2_decap_8
Xhold3145 _8041_/A _9029_/Q VPWR VGND sg13g2_dlygate4sd3_1
Xhold3156 _8321_/A _9161_/Q VPWR VGND sg13g2_dlygate4sd3_1
Xhold3167 _8255_/A _9128_/Q VPWR VGND sg13g2_dlygate4sd3_1
Xhold3134 _8063_/A _9037_/Q VPWR VGND sg13g2_dlygate4sd3_1
X_8016_ _9018_/D _5372_/C _8007_/A _8015_/Y VPWR VGND sg13g2_o21ai_1
XFILLER_102_178 VPWR VGND sg13g2_fill_2
XFILLER_102_167 VPWR VGND sg13g2_decap_8
XFILLER_102_156 VPWR VGND sg13g2_decap_4
Xhold3178 _6594_/A _9430_/Q VPWR VGND sg13g2_dlygate4sd3_1
XFILLER_76_519 VPWR VGND sg13g2_fill_1
Xhold3189 _8333_/A _9167_/Q VPWR VGND sg13g2_dlygate4sd3_1
X_5228_ _5260_/C _5238_/A _9871_/A _9872_/A VPWR VGND sg13g2_and3_1
XFILLER_69_571 VPWR VGND sg13g2_fill_1
XFILLER_29_402 VPWR VGND sg13g2_decap_4
X_5159_ _5159_/Y _5187_/A _8517_/B _5159_/C VPWR VGND sg13g2_nor3_1
XFILLER_72_714 VPWR VGND sg13g2_fill_2
XFILLER_17_619 VPWR VGND sg13g2_decap_8
XFILLER_71_202 VPWR VGND sg13g2_decap_8
XFILLER_16_107 VPWR VGND sg13g2_decap_8
X_8918_ _8918_/Q _9615_/CLK _8918_/D place2417/X VPWR VGND sg13g2_dfrbpq_1
XFILLER_71_279 VPWR VGND sg13g2_fill_1
XFILLER_52_471 VPWR VGND sg13g2_fill_2
X_8849_ _8849_/Q _9253_/CLK _8849_/D place2477/X VPWR VGND sg13g2_dfrbpq_1
XFILLER_52_482 VPWR VGND sg13g2_decap_8
XFILLER_12_368 VPWR VGND sg13g2_fill_1
XFILLER_20_390 VPWR VGND sg13g2_fill_1
XFILLER_106_484 VPWR VGND sg13g2_decap_8
XFILLER_4_578 VPWR VGND sg13g2_decap_8
XFILLER_121_432 VPWR VGND sg13g2_decap_4
XFILLER_79_346 VPWR VGND sg13g2_decap_8
XFILLER_79_335 VPWR VGND sg13g2_fill_2
XFILLER_48_744 VPWR VGND sg13g2_fill_2
XFILLER_47_265 VPWR VGND sg13g2_decap_8
XFILLER_90_511 VPWR VGND sg13g2_fill_1
XFILLER_90_500 VPWR VGND sg13g2_decap_8
XFILLER_62_235 VPWR VGND sg13g2_fill_2
XFILLER_16_641 VPWR VGND sg13g2_fill_2
XFILLER_30_121 VPWR VGND sg13g2_fill_1
XFILLER_30_143 VPWR VGND sg13g2_fill_1
XFILLER_30_176 VPWR VGND sg13g2_decap_4
XFILLER_30_187 VPWR VGND sg13g2_fill_1
X_4530_ _7032_/B _7431_/A _7705_/A _7705_/B VPWR VGND sg13g2_and3_1
XFILLER_7_42 VPWR VGND sg13g2_decap_8
XFILLER_117_738 VPWR VGND sg13g2_fill_2
X_4461_ _6569_/B _4462_/A _9693_/Q VPWR VGND sg13g2_and2_1
X_6200_ _6200_/Y _6161_/A _6399_/B _6199_/Y VPWR VGND sg13g2_o21ai_1
X_7180_ _7180_/Y _5358_/C _6978_/Y _7179_/Y VPWR VGND sg13g2_o21ai_1
X_6131_ _6131_/Y _6131_/A _6131_/B _6131_/C _6131_/D VPWR VGND sg13g2_nand4_1
X_4392_ _8676_/D _4392_/A _5438_/B_N VPWR VGND sg13g2_nor2b_1
XFILLER_98_655 VPWR VGND sg13g2_decap_8
Xfanout808 _6338_/B _6033_/B VPWR VGND sg13g2_buf_1
XFILLER_112_465 VPWR VGND sg13g2_fill_2
X_6062_ _6189_/C _6451_/A _6399_/A VPWR VGND sg13g2_nand2_1
XFILLER_23_0 VPWR VGND sg13g2_decap_8
X_5013_ _5013_/Y _9406_/Q _4972_/B _4959_/A _5012_/Y VPWR VGND sg13g2_a22oi_1
XFILLER_66_563 VPWR VGND sg13g2_fill_2
XFILLER_66_552 VPWR VGND sg13g2_fill_2
XFILLER_81_511 VPWR VGND sg13g2_fill_2
XFILLER_53_246 VPWR VGND sg13g2_decap_8
X_6964_ _6964_/Y _7036_/C _7179_/D _6961_/Y VPWR VGND sg13g2_a21oi_1
X_6895_ _6895_/X _8921_/Q _8953_/Q _6901_/S VPWR VGND sg13g2_mux2_1
X_5915_ _5917_/A _5915_/A1 _5952_/A _5914_/Y VPWR VGND sg13g2_o21ai_1
X_8703_ _8703_/Q _9675_/CLK _8703_/D place2444/X VPWR VGND sg13g2_dfrbpq_1
XFILLER_81_588 VPWR VGND sg13g2_fill_2
XFILLER_34_460 VPWR VGND sg13g2_fill_1
X_9683_ _9683_/Q _9689_/CLK _9683_/D fanout963/X VPWR VGND sg13g2_dfrbpq_1
X_5846_ _5846_/Y _5840_/Y _5845_/Y _5935_/A2 VPWR VGND sg13g2_a21oi_1
X_8634_ _8634_/Q _9645_/CLK _8634_/D fanout979/X VPWR VGND sg13g2_dfrbpq_1
XFILLER_34_471 VPWR VGND sg13g2_decap_8
XFILLER_22_677 VPWR VGND sg13g2_fill_1
X_5777_ _5777_/X _9318_/Q _9334_/Q _9310_/Q _9326_/Q _5938_/A _5843_/A2 VPWR VGND
+ sg13g2_mux4_1
X_8565_ _8565_/Y _8577_/A _8577_/B _9275_/Q VPWR VGND sg13g2_nand3_1
XFILLER_22_688 VPWR VGND sg13g2_fill_2
X_7516_ _7516_/Y _8797_/Q _7660_/A2 _7640_/A2 _9871_/A _7515_/Y VPWR VGND sg13g2_a221oi_1
X_8496_ _8496_/Y _8496_/A _8496_/B _9253_/Q VPWR VGND sg13g2_nand3_1
X_4728_ _4729_/B _9685_/Q _4728_/B VPWR VGND sg13g2_nor2_1
X_4659_ _9648_/D _4659_/A _4659_/B VPWR VGND sg13g2_nor2_1
X_7447_ _7448_/C _7492_/A _9124_/Q _7490_/C VPWR VGND sg13g2_nor3_1
Xplace2240 _7404_/C _7410_/A VPWR VGND sg13g2_buf_1
Xplace2262 _7351_/B _7404_/B VPWR VGND sg13g2_buf_1
Xplace2273 _7492_/B _7819_/B VPWR VGND sg13g2_buf_1
Xplace2251 _7819_/C _7296_/C VPWR VGND sg13g2_buf_1
X_7378_ _7378_/Y _7377_/Y _7372_/Y _7459_/A VPWR VGND sg13g2_a21oi_1
Xplace2295 _4823_/B _4827_/A VPWR VGND sg13g2_buf_1
Xplace2284 _5017_/A1 _4903_/A VPWR VGND sg13g2_buf_1
XFILLER_89_655 VPWR VGND sg13g2_fill_1
XFILLER_88_121 VPWR VGND sg13g2_fill_2
X_9117_ _9117_/Q _9183_/CLK _9117_/D place2469/X VPWR VGND sg13g2_dfrbpq_1
X_6329_ _6329_/Y _6415_/A1 _6470_/A2 _6329_/B1 VPWR VGND sg13g2_a21oi_1
XFILLER_103_465 VPWR VGND sg13g2_decap_8
X_9048_ _9048_/Q _9198_/CLK _9048_/D place2436/X VPWR VGND sg13g2_dfrbpq_1
XFILLER_76_338 VPWR VGND sg13g2_decap_8
XFILLER_123_42 VPWR VGND sg13g2_decap_8
XFILLER_29_254 VPWR VGND sg13g2_decap_8
XFILLER_84_371 VPWR VGND sg13g2_fill_1
XFILLER_45_747 VPWR VGND sg13g2_fill_2
XFILLER_25_482 VPWR VGND sg13g2_decap_4
XFILLER_13_677 VPWR VGND sg13g2_fill_1
XFILLER_8_136 VPWR VGND sg13g2_decap_8
XFILLER_8_147 VPWR VGND sg13g2_fill_1
XFILLER_32_72 VPWR VGND sg13g2_fill_2
XFILLER_4_397 VPWR VGND sg13g2_decap_8
XFILLER_95_647 VPWR VGND sg13g2_fill_1
XFILLER_95_636 VPWR VGND sg13g2_decap_8
XFILLER_94_113 VPWR VGND sg13g2_decap_4
XFILLER_79_176 VPWR VGND sg13g2_fill_2
XFILLER_57_80 VPWR VGND sg13g2_fill_1
XFILLER_63_522 VPWR VGND sg13g2_decap_4
XFILLER_35_202 VPWR VGND sg13g2_fill_2
Xclkbuf_leaf_12_jtag_tck_i_regs _9588_/CLK clkload26/A VPWR VGND sg13g2_buf_16
XFILLER_36_747 VPWR VGND sg13g2_decap_8
XFILLER_36_769 VPWR VGND sg13g2_fill_2
XFILLER_90_352 VPWR VGND sg13g2_decap_8
XFILLER_63_588 VPWR VGND sg13g2_decap_8
XFILLER_35_257 VPWR VGND sg13g2_decap_8
XFILLER_35_268 VPWR VGND sg13g2_fill_2
XFILLER_35_279 VPWR VGND sg13g2_decap_4
XFILLER_50_227 VPWR VGND sg13g2_fill_2
X_5700_ _8603_/D _5700_/A VPWR VGND sg13g2_inv_1
X_6680_ _6680_/Y _4651_/C _4649_/X _9457_/Q VPWR VGND sg13g2_o21ai_1
X_5631_ _5631_/Y _5631_/A _5631_/B VPWR VGND sg13g2_nor2_1
X_5562_ _5562_/Y _8643_/Q _5592_/A2 _5580_/B1 _8642_/Q VPWR VGND sg13g2_a22oi_1
X_8350_ _9175_/D _8350_/A1 _7957_/Y _8349_/Y VPWR VGND sg13g2_o21ai_1
X_4513_ _7006_/C _9504_/Q _5073_/A _4513_/C VPWR VGND sg13g2_nand3_1
X_7301_ _7304_/B _8786_/Q _7301_/B VPWR VGND sg13g2_nand2_1
X_8281_ _8281_/Y _8281_/A _8287_/B VPWR VGND sg13g2_nand2_1
X_5493_ _5494_/A _9588_/Q _6803_/B _5493_/C VPWR VGND sg13g2_nand3_1
X_7232_ _7232_/Y _7236_/A _7232_/B _7236_/C _7236_/D VPWR VGND sg13g2_nand4_1
X_4444_ _4446_/A _7232_/B _7228_/B _6979_/A _7236_/B VPWR VGND sg13g2_nor4_1
X_4375_ _4376_/B _9645_/Q _9649_/Q VPWR VGND sg13g2_nor2_1
X_7163_ _7163_/Y _5353_/C _6978_/Y _7162_/Y VPWR VGND sg13g2_o21ai_1
XFILLER_113_785 VPWR VGND sg13g2_decap_4
XFILLER_113_763 VPWR VGND sg13g2_decap_4
X_6114_ _6114_/Y _6438_/B _6189_/C _6369_/B _6103_/B VPWR VGND sg13g2_a22oi_1
X_7094_ _7094_/Y _5362_/C _7130_/A2 _7093_/Y VPWR VGND sg13g2_o21ai_1
XFILLER_86_636 VPWR VGND sg13g2_decap_8
XFILLER_58_349 VPWR VGND sg13g2_decap_8
XFILLER_58_327 VPWR VGND sg13g2_fill_2
X_6045_ _6049_/D _6024_/A _6018_/C _6031_/C VPWR VGND sg13g2_o21ai_1
XFILLER_73_308 VPWR VGND sg13g2_decap_4
XFILLER_39_541 VPWR VGND sg13g2_decap_8
XFILLER_54_511 VPWR VGND sg13g2_fill_1
XFILLER_27_736 VPWR VGND sg13g2_fill_1
XFILLER_53_27 VPWR VGND sg13g2_fill_2
XFILLER_53_16 VPWR VGND sg13g2_decap_8
XFILLER_26_257 VPWR VGND sg13g2_decap_4
X_7996_ _9008_/D _5362_/C _8019_/A _7995_/Y VPWR VGND sg13g2_o21ai_1
X_6947_ _6952_/S _6560_/B _6546_/Y _6562_/A _6951_/C _6946_/Y VPWR VGND sg13g2_a221oi_1
XFILLER_41_216 VPWR VGND sg13g2_fill_1
XFILLER_42_739 VPWR VGND sg13g2_fill_2
X_6878_ _9605_/D _6877_/X _9605_/Q _6900_/S VPWR VGND sg13g2_mux2_1
X_9666_ _9666_/Q _9672_/CLK _9666_/D place2441/X VPWR VGND sg13g2_dfrbpq_1
X_9597_ _9597_/Q _9603_/CLK _9597_/D _9597_/RESET_B VPWR VGND sg13g2_dfrbpq_1
X_5829_ _6003_/S _6523_/A _5828_/Y _5787_/C VPWR VGND sg13g2_a21oi_1
XFILLER_50_794 VPWR VGND sg13g2_fill_2
X_8617_ _8617_/Q _9689_/CLK _8617_/D fanout949/X VPWR VGND sg13g2_dfrbpq_1
X_8548_ _8549_/A _9267_/Q _8560_/A2 _8560_/B1 _9486_/Q VPWR VGND sg13g2_a22oi_1
X_8479_ _9244_/D _8490_/A _5359_/C _8478_/Y VPWR VGND sg13g2_o21ai_1
Xplace2081 _6004_/C _5954_/A VPWR VGND sg13g2_buf_1
Xplace2070 _8102_/A1 _6994_/D VPWR VGND sg13g2_buf_1
XFILLER_78_46 VPWR VGND sg13g2_decap_8
Xplace2092 _7775_/D _5382_/C VPWR VGND sg13g2_buf_1
XFILLER_78_79 VPWR VGND sg13g2_fill_2
XFILLER_78_68 VPWR VGND sg13g2_decap_8
XFILLER_77_603 VPWR VGND sg13g2_fill_2
XFILLER_94_23 VPWR VGND sg13g2_fill_1
XFILLER_92_617 VPWR VGND sg13g2_decap_8
Xclkbuf_leaf_18_clk_i _9252_/CLK clkbuf_3_6__f_clk_i/X VPWR VGND sg13g2_buf_16
XFILLER_94_78 VPWR VGND sg13g2_decap_4
XFILLER_91_149 VPWR VGND sg13g2_fill_2
XFILLER_84_190 VPWR VGND sg13g2_decap_8
XFILLER_33_728 VPWR VGND sg13g2_fill_1
XFILLER_32_216 VPWR VGND sg13g2_decap_8
XFILLER_60_569 VPWR VGND sg13g2_fill_2
XFILLER_32_249 VPWR VGND sg13g2_decap_8
XFILLER_41_783 VPWR VGND sg13g2_fill_2
XFILLER_4_21 VPWR VGND sg13g2_decap_8
XFILLER_4_87 VPWR VGND sg13g2_fill_1
XFILLER_110_766 VPWR VGND sg13g2_fill_2
XFILLER_110_788 VPWR VGND sg13g2_fill_2
XFILLER_82_116 VPWR VGND sg13g2_fill_1
XFILLER_55_308 VPWR VGND sg13g2_fill_1
X_7850_ _8927_/D _7883_/S _7242_/Y _7849_/Y VPWR VGND sg13g2_a21oi_1
XFILLER_91_650 VPWR VGND sg13g2_decap_8
X_6801_ _9553_/D _9547_/Q _4712_/X _6800_/Y VPWR VGND sg13g2_o21ai_1
X_9604__2786 _9604_/RESET_B VPWR VGND sg13g2_tiehi
XFILLER_90_171 VPWR VGND sg13g2_fill_2
X_7781_ _7785_/B _7783_/C _7803_/B _8986_/Q VPWR VGND sg13g2_nor3_1
X_4993_ _4993_/Y _5006_/A1 _4990_/Y _4992_/Y VPWR VGND sg13g2_o21ai_1
XFILLER_17_780 VPWR VGND sg13g2_decap_4
X_9520_ _9520_/Q _9567_/CLK _9520_/D _9520_/RESET_B VPWR VGND sg13g2_dfrbpq_1
XFILLER_90_0 VPWR VGND sg13g2_decap_8
X_6732_ _9500_/D _9541_/Q _9500_/Q _6733_/S VPWR VGND sg13g2_mux2_1
X_6663_ _9450_/D _6663_/A1 _6662_/Y _6660_/Y VPWR VGND sg13g2_o21ai_1
X_9451_ _9451_/Q _9587_/CLK _9451_/D fanout979/X VPWR VGND sg13g2_dfrbpq_1
X_8402_ _9201_/D _5369_/C _8401_/A _8401_/Y VPWR VGND sg13g2_o21ai_1
X_5614_ _8659_/D _5613_/Y _5612_/Y _5623_/B1 VPWR VGND sg13g2_a21oi_1
X_6594_ _6594_/Y _6594_/A _6660_/B VPWR VGND sg13g2_nand2_1
X_9382_ _9382_/Q _9414_/CLK _9382_/D place2501/X VPWR VGND sg13g2_dfrbpq_1
X_5545_ _8636_/D _5544_/Y _5543_/Y _5593_/B1 VPWR VGND sg13g2_a21oi_1
X_8333_ _8333_/Y _8333_/A _8343_/B VPWR VGND sg13g2_nand2_1
X_8264_ _9132_/D _8288_/A1 _8068_/Y _8263_/Y VPWR VGND sg13g2_o21ai_1
X_5476_ _8696_/D _5476_/A _6737_/C VPWR VGND sg13g2_nor2b_1
X_8195_ _8195_/Y _8195_/A _8219_/B VPWR VGND sg13g2_nand2_1
X_7215_ _7215_/Y _7237_/A1 _9495_/Q _7237_/B1 _7237_/B2 VPWR VGND sg13g2_a22oi_1
X_4427_ _6103_/B _9244_/Q _6451_/B _9243_/Q _6451_/D VPWR VGND sg13g2_nor4_1
X_7146_ _7146_/Y _7897_/D _6977_/Y _7132_/Y _4435_/B VPWR VGND sg13g2_a22oi_1
Xclkbuf_leaf_7_jtag_tck_i_regs _9645_/CLK clkbuf_leaf_9_jtag_tck_i_regs/A VPWR VGND
+ sg13g2_buf_16
XFILLER_86_433 VPWR VGND sg13g2_fill_2
X_4358_ _6798_/B _9679_/Q _4358_/B VPWR VGND sg13g2_nor2_1
X_7077_ _7077_/Y _7175_/B _7182_/D _7080_/C VPWR VGND sg13g2_nand3_1
XFILLER_100_276 VPWR VGND sg13g2_fill_2
XFILLER_73_116 VPWR VGND sg13g2_fill_2
X_6028_ _6410_/A _6035_/A _6037_/C VPWR VGND sg13g2_nor2_1
XFILLER_27_511 VPWR VGND sg13g2_fill_2
XFILLER_39_371 VPWR VGND sg13g2_fill_2
XFILLER_27_533 VPWR VGND sg13g2_fill_2
XFILLER_82_650 VPWR VGND sg13g2_fill_2
XFILLER_64_37 VPWR VGND sg13g2_decap_8
XFILLER_120_21 VPWR VGND sg13g2_decap_8
X_7979_ _7979_/Y _7979_/A _9000_/Q _8371_/C VPWR VGND sg13g2_nand3_1
XFILLER_42_514 VPWR VGND sg13g2_fill_2
X_9649_ _9649_/Q _9649_/CLK _9649_/D fanout973/X VPWR VGND sg13g2_dfrbpq_1
XFILLER_13_52 VPWR VGND sg13g2_decap_8
XFILLER_123_302 VPWR VGND sg13g2_decap_8
XFILLER_123_357 VPWR VGND sg13g2_decap_8
XFILLER_96_219 VPWR VGND sg13g2_fill_2
XFILLER_96_208 VPWR VGND sg13g2_decap_8
XFILLER_2_654 VPWR VGND sg13g2_fill_1
XFILLER_104_593 VPWR VGND sg13g2_decap_8
XFILLER_104_571 VPWR VGND sg13g2_decap_4
XFILLER_89_282 VPWR VGND sg13g2_decap_8
XFILLER_2_698 VPWR VGND sg13g2_fill_1
Xfanout980 fanout980/X fanout981/X VPWR VGND sg13g2_buf_1
XFILLER_92_414 VPWR VGND sg13g2_fill_1
XFILLER_64_116 VPWR VGND sg13g2_fill_1
XFILLER_92_458 VPWR VGND sg13g2_fill_2
XFILLER_58_680 VPWR VGND sg13g2_decap_4
XFILLER_60_311 VPWR VGND sg13g2_fill_2
XFILLER_60_388 VPWR VGND sg13g2_decap_8
XFILLER_9_242 VPWR VGND sg13g2_decap_4
XFILLER_118_118 VPWR VGND sg13g2_decap_8
Xclkload34 clkload34/Y _9645_/CLK VPWR VGND sg13g2_inv_2
Xclkload23 clkload23/Y _9219_/CLK VPWR VGND sg13g2_inv_1
XFILLER_62_4 VPWR VGND sg13g2_fill_1
Xclkload12 clkload12/Y _9251_/CLK VPWR VGND sg13g2_inv_2
X_5330_ _5330_/Y _5330_/A _5330_/B VPWR VGND sg13g2_nand2_1
X_5261_ _5261_/Y _5334_/A _5286_/B _5288_/A1 VPWR VGND sg13g2_a21oi_1
XFILLER_5_492 VPWR VGND sg13g2_decap_8
XFILLER_88_709 VPWR VGND sg13g2_decap_8
X_7000_ _7000_/Y _6999_/Y _6993_/Y _5377_/X VPWR VGND sg13g2_a21oi_1
X_5192_ _5192_/Y _5192_/A _5192_/B _5192_/C _5192_/D VPWR VGND sg13g2_nand4_1
XFILLER_96_764 VPWR VGND sg13g2_decap_8
XFILLER_68_444 VPWR VGND sg13g2_decap_8
X_8951_ _8951_/Q _9615_/CLK _8951_/D place2418/X VPWR VGND sg13g2_dfrbpq_1
XFILLER_83_425 VPWR VGND sg13g2_fill_2
XFILLER_68_499 VPWR VGND sg13g2_fill_2
XFILLER_56_628 VPWR VGND sg13g2_decap_4
XFILLER_55_138 VPWR VGND sg13g2_fill_2
X_7902_ _7902_/Y _8039_/A _8039_/B _8039_/C _7902_/D VPWR VGND sg13g2_nand4_1
XFILLER_71_609 VPWR VGND sg13g2_fill_1
X_8882_ _8882_/Q _9253_/CLK _8882_/D place2487/X VPWR VGND sg13g2_dfrbpq_1
XFILLER_51_300 VPWR VGND sg13g2_decap_8
X_7833_ _7836_/B _9175_/Q _7838_/B VPWR VGND sg13g2_nor2_1
X_7764_ _7768_/C _9202_/Q _7627_/B _7801_/A VPWR VGND sg13g2_o21ai_1
XFILLER_51_333 VPWR VGND sg13g2_decap_8
X_6715_ _9483_/D _9524_/Q _9483_/Q _6736_/S VPWR VGND sg13g2_mux2_1
X_9503_ _9503_/Q _9504_/CLK _9503_/D _9503_/RESET_B VPWR VGND sg13g2_dfrbpq_1
XFILLER_11_219 VPWR VGND sg13g2_decap_4
X_4976_ _4977_/B _4999_/B _4813_/Y _4938_/Y _4812_/Y _4821_/Y VPWR VGND sg13g2_a221oi_1
X_7695_ _7696_/D _9219_/Q _7695_/A2 _7846_/B1 _7695_/B2 VPWR VGND sg13g2_a22oi_1
XFILLER_20_720 VPWR VGND sg13g2_decap_8
XFILLER_20_742 VPWR VGND sg13g2_fill_1
X_6646_ _6646_/Y _6642_/C _8647_/Q _9579_/Q _6655_/B2 VPWR VGND sg13g2_a22oi_1
X_9434_ _9434_/Q _9449_/CLK _9434_/D fanout980/X VPWR VGND sg13g2_dfrbpq_1
Xclkload6 clkload6/X clkload6/A VPWR VGND sg13g2_buf_16
XFILLER_20_775 VPWR VGND sg13g2_decap_8
XFILLER_118_630 VPWR VGND sg13g2_fill_2
X_6577_ _6577_/Y _9425_/Q _6587_/B VPWR VGND sg13g2_nand2_1
X_9365_ _9365_/Q clkload9/A _9365_/D place2492/X VPWR VGND sg13g2_dfrbpq_1
XFILLER_105_302 VPWR VGND sg13g2_decap_8
X_5528_ _5528_/Y _5597_/A _5597_/B _8632_/Q _5597_/D VPWR VGND sg13g2_nand4_1
X_8316_ _9158_/D _7028_/D _8056_/Y _8315_/Y VPWR VGND sg13g2_o21ai_1
X_9296_ _9296_/Q _9615_/CLK _9296_/D place2419/X VPWR VGND sg13g2_dfrbpq_1
XFILLER_117_184 VPWR VGND sg13g2_decap_8
Xoutput2682 master_addr_o[29] _9887_/X VPWR VGND sg13g2_buf_1
Xoutput2671 master_addr_o[19] _9877_/X VPWR VGND sg13g2_buf_1
Xoutput2660 jtag_tdo_oe_o _8664_/Q VPWR VGND sg13g2_buf_1
X_5459_ _5460_/A _5469_/A1 _8688_/Q _8689_/Q _5467_/B2 VPWR VGND sg13g2_a22oi_1
X_8247_ _8247_/Y _9124_/Q _8251_/B VPWR VGND sg13g2_nand2_1
XFILLER_99_591 VPWR VGND sg13g2_decap_8
Xoutput2693 master_be_o[0] _5046_/Y VPWR VGND sg13g2_buf_1
X_8178_ _9089_/D _8198_/A1 _7902_/Y _8177_/Y VPWR VGND sg13g2_o21ai_1
X_7129_ _7129_/Y _7236_/B _7236_/D _7129_/C VPWR VGND sg13g2_nand3_1
XFILLER_101_563 VPWR VGND sg13g2_decap_4
XFILLER_101_552 VPWR VGND sg13g2_decap_8
XFILLER_47_628 VPWR VGND sg13g2_fill_2
XFILLER_46_116 VPWR VGND sg13g2_decap_8
XFILLER_46_127 VPWR VGND sg13g2_fill_1
XFILLER_54_193 VPWR VGND sg13g2_fill_2
XFILLER_10_274 VPWR VGND sg13g2_decap_8
XFILLER_109_674 VPWR VGND sg13g2_fill_1
XFILLER_109_663 VPWR VGND sg13g2_fill_1
XFILLER_6_256 VPWR VGND sg13g2_decap_8
XFILLER_123_154 VPWR VGND sg13g2_decap_8
XFILLER_123_187 VPWR VGND sg13g2_decap_8
XFILLER_93_701 VPWR VGND sg13g2_decap_8
XFILLER_38_628 VPWR VGND sg13g2_decap_8
XFILLER_65_425 VPWR VGND sg13g2_fill_1
XFILLER_93_778 VPWR VGND sg13g2_fill_1
XFILLER_92_255 VPWR VGND sg13g2_decap_8
XFILLER_80_428 VPWR VGND sg13g2_fill_1
XFILLER_33_333 VPWR VGND sg13g2_decap_8
X_4830_ _4831_/B _4825_/Y _4829_/Y _4821_/Y VPWR VGND sg13g2_a21oi_1
X_9513__2867 _9513_/RESET_B VPWR VGND sg13g2_tiehi
X_4761_ _4761_/X _4928_/B _4814_/B VPWR VGND sg13g2_or2_1
X_7480_ _7484_/A _9286_/Q _7557_/A2 _7557_/B1 _9318_/Q VPWR VGND sg13g2_a22oi_1
X_4692_ _4693_/C _8739_/Q _4692_/B VPWR VGND sg13g2_nor2_1
X_6500_ _6500_/Y _9081_/Q _6506_/B1 _6507_/B1 _9143_/Q VPWR VGND sg13g2_a22oi_1
XFILLER_119_449 VPWR VGND sg13g2_decap_8
X_6431_ _6431_/Y _6398_/Y _6431_/B VPWR VGND sg13g2_nand2b_1
Xplace1902 _6312_/C _6512_/A1 VPWR VGND sg13g2_buf_1
X_9150_ _9150_/Q clkload5/A _9150_/D place2498/X VPWR VGND sg13g2_dfrbpq_1
X_6362_ _6362_/Y _6373_/A1 _6373_/A2 _9381_/Q VPWR VGND sg13g2_a21oi_1
X_5313_ _5334_/B _9884_/A _9885_/A _5313_/C _5314_/D VPWR VGND sg13g2_and4_1
Xplace1935 _7846_/B1 _7737_/B1 VPWR VGND sg13g2_buf_1
Xplace1913 _7010_/A _8092_/C VPWR VGND sg13g2_buf_1
Xplace1946 _7788_/B1 _6960_/Y VPWR VGND sg13g2_buf_1
XFILLER_53_0 VPWR VGND sg13g2_decap_8
XFILLER_6_790 VPWR VGND sg13g2_fill_1
Xplace1924 _6371_/A _6021_/X VPWR VGND sg13g2_buf_1
X_8101_ _8101_/Y _9051_/Q _8101_/B VPWR VGND sg13g2_nand2_1
Xplace1968 _7796_/B1 _7843_/B1 VPWR VGND sg13g2_buf_1
Xplace1979 _8563_/D _7024_/D VPWR VGND sg13g2_buf_1
X_6293_ _6293_/X _8985_/Q _9047_/Q _9109_/Q _9171_/Q _6480_/S0 _6480_/S1 VPWR VGND
+ sg13g2_mux4_1
Xplace1957 _6401_/B2 _6430_/B2 VPWR VGND sg13g2_buf_1
X_9081_ _9081_/Q clkload8/A _9081_/D place2465/X VPWR VGND sg13g2_dfrbpq_1
X_5244_ _5244_/Y _5244_/A _5244_/B VPWR VGND sg13g2_nand2_1
X_8032_ _9025_/D _8100_/A1 _7897_/Y _8031_/Y VPWR VGND sg13g2_o21ai_1
X_5175_ _5176_/B _5178_/D _5175_/B _5175_/C _5178_/A VPWR VGND sg13g2_nand4_1
XFILLER_29_29 VPWR VGND sg13g2_fill_1
XFILLER_83_211 VPWR VGND sg13g2_decap_4
XFILLER_83_200 VPWR VGND sg13g2_fill_2
X_8934_ _8934_/Q _9620_/CLK _8934_/D place2438/X VPWR VGND sg13g2_dfrbpq_1
XFILLER_37_661 VPWR VGND sg13g2_fill_1
XFILLER_83_288 VPWR VGND sg13g2_decap_8
XFILLER_71_439 VPWR VGND sg13g2_fill_2
XFILLER_71_428 VPWR VGND sg13g2_decap_8
X_8865_ _8865_/Q _9692_/CLK _8865_/D place2496/X VPWR VGND sg13g2_dfrbpq_1
XFILLER_37_683 VPWR VGND sg13g2_fill_2
X_7816_ _7817_/C _9174_/Q _7816_/B VPWR VGND sg13g2_nor2_1
X_8796_ _8796_/Q _9252_/CLK _8796_/D place2401/X VPWR VGND sg13g2_dfrbpq_1
X_7747_ _7749_/C _7747_/A _9139_/Q _7747_/C VPWR VGND sg13g2_nor3_1
XFILLER_12_539 VPWR VGND sg13g2_decap_8
X_4959_ _4960_/D _4959_/A _4959_/B _4959_/C _4983_/B VPWR VGND sg13g2_nand4_1
X_7678_ _8917_/D _8917_/Q _7677_/Y _7774_/S VPWR VGND sg13g2_mux2_1
Xinput2558 _7770_/B2 hartinfo_i[26] VPWR VGND sg13g2_buf_1
Xinput2547 _7559_/B2 hartinfo_i[16] VPWR VGND sg13g2_buf_1
X_6629_ _6629_/Y _6642_/C _8642_/Q _9574_/Q _6655_/B2 VPWR VGND sg13g2_a22oi_1
Xinput2569 _7392_/B2 hartinfo_i[7] VPWR VGND sg13g2_buf_1
X_9417_ _9417_/Q _9701_/CLK _9417_/D fanout957/X VPWR VGND sg13g2_dfrbpq_1
XFILLER_4_705 VPWR VGND sg13g2_fill_2
XFILLER_106_633 VPWR VGND sg13g2_decap_8
X_9348_ _9348_/Q _9692_/CLK _9348_/D place2502/X VPWR VGND sg13g2_dfrbpq_1
X_9279_ _9279_/Q _9410_/CLK _9279_/D place2405/X VPWR VGND sg13g2_dfrbpq_1
XFILLER_105_132 VPWR VGND sg13g2_decap_4
XFILLER_79_506 VPWR VGND sg13g2_decap_4
XFILLER_10_42 VPWR VGND sg13g2_decap_8
XFILLER_3_237 VPWR VGND sg13g2_decap_8
XFILLER_120_146 VPWR VGND sg13g2_fill_1
XFILLER_105_198 VPWR VGND sg13g2_fill_2
XFILLER_87_550 VPWR VGND sg13g2_decap_4
X_9563__2827 _9563_/RESET_B VPWR VGND sg13g2_tiehi
XFILLER_101_393 VPWR VGND sg13g2_fill_1
XFILLER_87_594 VPWR VGND sg13g2_decap_8
XFILLER_75_745 VPWR VGND sg13g2_decap_8
XFILLER_47_436 VPWR VGND sg13g2_fill_1
XFILLER_75_789 VPWR VGND sg13g2_fill_1
XFILLER_90_748 VPWR VGND sg13g2_decap_8
XFILLER_15_311 VPWR VGND sg13g2_decap_8
XFILLER_27_171 VPWR VGND sg13g2_fill_2
XFILLER_28_683 VPWR VGND sg13g2_fill_2
XFILLER_15_322 VPWR VGND sg13g2_fill_2
XFILLER_15_377 VPWR VGND sg13g2_decap_4
XFILLER_43_664 VPWR VGND sg13g2_decap_4
XFILLER_42_174 VPWR VGND sg13g2_decap_8
XFILLER_11_594 VPWR VGND sg13g2_decap_8
XFILLER_112_647 VPWR VGND sg13g2_decap_8
XFILLER_2_270 VPWR VGND sg13g2_fill_2
XFILLER_78_572 VPWR VGND sg13g2_decap_8
XFILLER_38_403 VPWR VGND sg13g2_fill_2
XFILLER_120_691 VPWR VGND sg13g2_decap_8
XFILLER_93_531 VPWR VGND sg13g2_decap_8
XFILLER_93_542 VPWR VGND sg13g2_fill_2
X_6980_ _6980_/Y _5375_/C _7222_/A2 _6979_/Y VPWR VGND sg13g2_o21ai_1
XFILLER_38_458 VPWR VGND sg13g2_decap_8
X_5931_ _5933_/A _5931_/A1 _5889_/S _5930_/Y VPWR VGND sg13g2_o21ai_1
XFILLER_65_299 VPWR VGND sg13g2_fill_1
XFILLER_53_439 VPWR VGND sg13g2_fill_2
XFILLER_34_642 VPWR VGND sg13g2_decap_4
X_8650_ _8650_/Q _9449_/CLK _8650_/D fanout971/X VPWR VGND sg13g2_dfrbpq_1
X_5862_ _5862_/Y _5856_/Y _5861_/X _5837_/Y VPWR VGND sg13g2_a21oi_1
X_8581_ _8582_/A _9283_/Q _8587_/A2 _8587_/B1 _9480_/Q VPWR VGND sg13g2_a22oi_1
X_5793_ _9289_/D _5793_/A VPWR VGND sg13g2_inv_1
X_7601_ _7615_/A _9292_/Q _7843_/A2 _7843_/B1 _9324_/Q _7600_/Y VPWR VGND sg13g2_a221oi_1
X_4813_ _4813_/Y _4813_/A _4816_/B _4816_/C VPWR VGND sg13g2_nor3_1
X_7532_ _7534_/D _9872_/A _7825_/A2 _7825_/B1 _7532_/B2 VPWR VGND sg13g2_a22oi_1
X_4744_ _9701_/D _4588_/Y _6937_/B _4744_/B1 VPWR VGND sg13g2_a21oi_1
XFILLER_119_279 VPWR VGND sg13g2_fill_1
X_4675_ _9652_/D _4675_/A _6690_/S VPWR VGND sg13g2_nor2_1
XFILLER_107_408 VPWR VGND sg13g2_decap_8
Xplace2411 place2411/X place2413/X VPWR VGND sg13g2_buf_1
X_9202_ _9202_/Q _9504_/CLK _9202_/D place2432/X VPWR VGND sg13g2_dfrbpq_1
Xplace2422 place2422/X place2454/X VPWR VGND sg13g2_buf_1
Xplace2400 place2400/X place2507/A VPWR VGND sg13g2_buf_1
X_7463_ _7466_/A _7469_/A _9125_/Q _7490_/C VPWR VGND sg13g2_nor3_1
Xplace2444 place2444/X place2450/X VPWR VGND sg13g2_buf_1
Xplace2433 place2433/X place2453/X VPWR VGND sg13g2_buf_1
X_7394_ _7395_/D _8498_/B _7482_/C _7579_/A2 _8840_/Q VPWR VGND sg13g2_a22oi_1
Xplace2455 place2455/X place2460/X VPWR VGND sg13g2_buf_1
X_6414_ _6414_/Y _8878_/Q _7176_/B2 _6413_/X _6422_/B1 VPWR VGND sg13g2_a22oi_1
X_9133_ _9133_/Q _9304_/CLK _9133_/D place2421/X VPWR VGND sg13g2_dfrbpq_1
Xplace2488 place2488/X place2507/X VPWR VGND sg13g2_buf_1
Xplace2499 place2499/X place2506/X VPWR VGND sg13g2_buf_1
X_6345_ _6347_/B _6371_/A _6371_/B _9377_/Q VPWR VGND sg13g2_o21ai_1
Xplace2466 place2466/X place2467/X VPWR VGND sg13g2_buf_1
Xplace2477 place2477/X place2479/X VPWR VGND sg13g2_buf_1
XFILLER_103_625 VPWR VGND sg13g2_fill_2
Xplace1776 _6654_/B _6660_/B VPWR VGND sg13g2_buf_1
Xhold3124 _8082_/A _9044_/Q VPWR VGND sg13g2_dlygate4sd3_1
Xhold3102 _8231_/A _9116_/Q VPWR VGND sg13g2_dlygate4sd3_1
Xhold3113 _8033_/A _9026_/Q VPWR VGND sg13g2_dlygate4sd3_1
X_9064_ _9064_/Q _9188_/CLK _9064_/D place2466/X VPWR VGND sg13g2_dfrbpq_1
Xplace1787 _8243_/B _8285_/B VPWR VGND sg13g2_buf_1
X_6276_ _6279_/B _9247_/Q _6254_/C _6287_/B VPWR VGND sg13g2_a21o_1
XFILLER_102_113 VPWR VGND sg13g2_decap_8
Xhold3146 _7946_/B _8985_/Q VPWR VGND sg13g2_dlygate4sd3_1
Xplace1798 _5274_/A1 _5080_/Y VPWR VGND sg13g2_buf_1
X_5227_ _5230_/A _5234_/C _5242_/C _5234_/A VPWR VGND sg13g2_o21ai_1
Xhold3157 _8343_/A _9172_/Q VPWR VGND sg13g2_dlygate4sd3_1
Xhold3135 _8245_/A _9123_/Q VPWR VGND sg13g2_dlygate4sd3_1
X_8015_ _8015_/Y _8017_/A _9018_/Q _8411_/C VPWR VGND sg13g2_nand3_1
Xhold3179 _8088_/A _9046_/Q VPWR VGND sg13g2_dlygate4sd3_1
Xhold3168 _4722_/A _8742_/Q VPWR VGND sg13g2_dlygate4sd3_1
XFILLER_111_680 VPWR VGND sg13g2_fill_1
X_5158_ _5188_/A _9864_/A _5178_/B _5178_/A _5158_/D VPWR VGND sg13g2_nand4_1
XFILLER_84_520 VPWR VGND sg13g2_fill_2
X_5089_ _5089_/Y _5089_/A _5089_/B VPWR VGND sg13g2_nand2_1
XFILLER_57_756 VPWR VGND sg13g2_fill_2
X_8917_ _8917_/Q _9615_/CLK _8917_/D place2416/X VPWR VGND sg13g2_dfrbpq_1
XFILLER_84_575 VPWR VGND sg13g2_fill_1
XFILLER_56_277 VPWR VGND sg13g2_decap_4
XFILLER_71_225 VPWR VGND sg13g2_fill_1
XFILLER_112_99 VPWR VGND sg13g2_fill_2
XFILLER_13_804 VPWR VGND sg13g2_fill_1
X_8848_ _8848_/Q _9253_/CLK _8848_/D place2463/X VPWR VGND sg13g2_dfrbpq_1
X_8779_ _9885_/A _9260_/CLK _8779_/D place2394/X VPWR VGND sg13g2_dfrbpq_1
X_9617__2773 _9617_/RESET_B VPWR VGND sg13g2_tiehi
XFILLER_4_557 VPWR VGND sg13g2_decap_8
XFILLER_0_730 VPWR VGND sg13g2_decap_8
XFILLER_0_741 VPWR VGND sg13g2_fill_1
Xhold2990 hold2990/X _8712_/Q VPWR VGND sg13g2_dlygate4sd3_1
XFILLER_47_244 VPWR VGND sg13g2_fill_2
XFILLER_90_523 VPWR VGND sg13g2_decap_8
XFILLER_35_417 VPWR VGND sg13g2_decap_8
XFILLER_35_428 VPWR VGND sg13g2_fill_1
XFILLER_47_299 VPWR VGND sg13g2_decap_8
XFILLER_94_7 VPWR VGND sg13g2_decap_4
XFILLER_15_163 VPWR VGND sg13g2_fill_1
XFILLER_31_612 VPWR VGND sg13g2_fill_1
XFILLER_31_623 VPWR VGND sg13g2_fill_2
XFILLER_43_494 VPWR VGND sg13g2_fill_2
XFILLER_30_133 VPWR VGND sg13g2_fill_2
XFILLER_7_21 VPWR VGND sg13g2_decap_8
XFILLER_30_199 VPWR VGND sg13g2_fill_2
XFILLER_116_216 VPWR VGND sg13g2_fill_2
XFILLER_7_65 VPWR VGND sg13g2_fill_1
X_4460_ _4462_/A _6915_/A _5629_/C _5629_/B _4460_/D VPWR VGND sg13g2_nand4_1
XFILLER_7_395 VPWR VGND sg13g2_decap_8
XFILLER_7_98 VPWR VGND sg13g2_decap_8
X_4391_ _4392_/A _4391_/A1 _5439_/A1 _4390_/Y VPWR VGND sg13g2_a21oi_1
X_6130_ _6131_/C _8839_/Q _6130_/B VPWR VGND sg13g2_nand2_1
Xclkbuf_1_1__f_i_dmi_jtag.i_dmi_jtag_tap.i_dft_tck_mux.clk_o _8663_/CLK clkbuf_0_i_dmi_jtag.i_dmi_jtag_tap.i_dft_tck_mux.clk_o/X
+ VPWR VGND sg13g2_buf_8
XFILLER_112_477 VPWR VGND sg13g2_decap_8
XFILLER_98_689 VPWR VGND sg13g2_decap_8
XFILLER_58_509 VPWR VGND sg13g2_decap_8
X_6061_ _6332_/C _6061_/A _6349_/S1 VPWR VGND sg13g2_nor2b_1
XFILLER_97_188 VPWR VGND sg13g2_fill_1
XFILLER_38_200 VPWR VGND sg13g2_decap_8
X_5012_ _5012_/Y _5012_/A _5012_/B _5012_/C _5012_/D VPWR VGND sg13g2_nand4_1
XFILLER_66_531 VPWR VGND sg13g2_decap_8
XFILLER_16_0 VPWR VGND sg13g2_decap_8
XFILLER_38_233 VPWR VGND sg13g2_decap_8
XFILLER_38_244 VPWR VGND sg13g2_fill_2
XFILLER_93_372 VPWR VGND sg13g2_fill_1
XFILLER_53_214 VPWR VGND sg13g2_decap_8
XFILLER_93_394 VPWR VGND sg13g2_decap_8
X_6963_ _7179_/D _7132_/A _7132_/B VPWR VGND sg13g2_nor2_1
X_5914_ _5914_/Y _5930_/A1 _5930_/A2 _5913_/Y VPWR VGND sg13g2_a21oi_1
X_6894_ _9613_/D _6893_/X _9613_/Q _6902_/S VPWR VGND sg13g2_mux2_1
X_8702_ _8702_/Q _9675_/CLK _8702_/D place2444/X VPWR VGND sg13g2_dfrbpq_1
X_9682_ _9682_/Q _9689_/CLK _9682_/D fanout963/X VPWR VGND sg13g2_dfrbpq_1
X_5845_ _5845_/Y _5938_/A _5841_/X _5844_/Y VPWR VGND sg13g2_o21ai_1
X_8633_ _8633_/Q _9645_/CLK _8633_/D fanout981/X VPWR VGND sg13g2_dfrbpq_1
X_8564_ _9274_/D _5830_/Y _8563_/X _8562_/Y VPWR VGND sg13g2_o21ai_1
X_5776_ _5776_/X _9317_/Q _9333_/Q _9309_/Q _9325_/Q _5938_/A _5843_/A2 VPWR VGND
+ sg13g2_mux4_1
X_7515_ _7515_/Y _7515_/A _7515_/B _7515_/C _7515_/D VPWR VGND sg13g2_nand4_1
X_8495_ _9252_/D _8494_/A _5375_/C _8494_/Y VPWR VGND sg13g2_o21ai_1
X_4727_ _4728_/B _9682_/Q _8742_/Q VPWR VGND sg13g2_nor2b_1
X_4658_ _4659_/B _9648_/Q _4658_/B VPWR VGND sg13g2_nor2_1
Xplace2230 _7744_/A _7667_/A VPWR VGND sg13g2_buf_1
X_7446_ _7448_/B _7492_/A _7492_/B _9093_/Q VPWR VGND sg13g2_nor3_1
XFILLER_116_750 VPWR VGND sg13g2_decap_8
Xplace2252 _7425_/C _7486_/A VPWR VGND sg13g2_buf_1
Xplace2263 _7404_/B _7834_/B VPWR VGND sg13g2_buf_1
Xplace2241 _7410_/A _9465_/Q VPWR VGND sg13g2_buf_1
X_7377_ _7377_/Y _8790_/Q _7660_/A2 _5383_/Y _9864_/A _7376_/Y VPWR VGND sg13g2_a221oi_1
X_9116_ _9116_/Q _9188_/CLK _9116_/D place2485/X VPWR VGND sg13g2_dfrbpq_1
XFILLER_1_505 VPWR VGND sg13g2_fill_1
Xplace2296 _4827_/A _9340_/Q VPWR VGND sg13g2_buf_1
X_4589_ _9697_/D _4743_/A _6939_/C _4589_/C VPWR VGND sg13g2_and3_1
Xplace2274 _7819_/B _7608_/B VPWR VGND sg13g2_buf_1
Xplace2285 _4813_/A _4903_/A VPWR VGND sg13g2_buf_1
XFILLER_107_55 VPWR VGND sg13g2_fill_1
XFILLER_107_44 VPWR VGND sg13g2_decap_8
XFILLER_88_133 VPWR VGND sg13g2_fill_2
XFILLER_88_111 VPWR VGND sg13g2_decap_4
X_6328_ _6328_/X _6328_/A _6328_/B _6328_/C VPWR VGND sg13g2_and3_1
XFILLER_89_678 VPWR VGND sg13g2_decap_4
X_9047_ _9047_/Q _9504_/CLK _9047_/D place2432/X VPWR VGND sg13g2_dfrbpq_1
XFILLER_49_509 VPWR VGND sg13g2_decap_8
X_6259_ _6259_/Y _4425_/Y _6270_/C _6173_/C VPWR VGND sg13g2_o21ai_1
XFILLER_88_188 VPWR VGND sg13g2_fill_1
X_9472__2908 _9472_/RESET_B VPWR VGND sg13g2_tiehi
XFILLER_123_21 VPWR VGND sg13g2_decap_8
XFILLER_72_501 VPWR VGND sg13g2_fill_1
XFILLER_57_597 VPWR VGND sg13g2_decap_4
XFILLER_17_417 VPWR VGND sg13g2_decap_8
XFILLER_29_288 VPWR VGND sg13g2_decap_8
XFILLER_44_214 VPWR VGND sg13g2_fill_2
XFILLER_123_98 VPWR VGND sg13g2_decap_8
XFILLER_25_461 VPWR VGND sg13g2_fill_1
XFILLER_12_122 VPWR VGND sg13g2_decap_8
XFILLER_8_115 VPWR VGND sg13g2_decap_8
XFILLER_120_0 VPWR VGND sg13g2_decap_8
XFILLER_113_208 VPWR VGND sg13g2_decap_8
XFILLER_107_772 VPWR VGND sg13g2_fill_1
XFILLER_106_293 VPWR VGND sg13g2_decap_8
XFILLER_122_753 VPWR VGND sg13g2_decap_8
XFILLER_67_339 VPWR VGND sg13g2_decap_8
XFILLER_95_659 VPWR VGND sg13g2_decap_8
XFILLER_48_542 VPWR VGND sg13g2_fill_1
XFILLER_90_331 VPWR VGND sg13g2_decap_8
XFILLER_75_383 VPWR VGND sg13g2_decap_4
XFILLER_51_707 VPWR VGND sg13g2_fill_2
XFILLER_16_483 VPWR VGND sg13g2_fill_1
XFILLER_44_781 VPWR VGND sg13g2_fill_2
XFILLER_44_792 VPWR VGND sg13g2_fill_1
XFILLER_31_431 VPWR VGND sg13g2_fill_1
X_5630_ _5631_/B _4457_/X _5629_/A _5630_/B1 VPWR VGND sg13g2_a21oi_1
X_5561_ _5561_/Y _6628_/A _5570_/B VPWR VGND sg13g2_nand2_1
XFILLER_117_514 VPWR VGND sg13g2_decap_8
X_8280_ _9140_/D _8284_/A1 _8092_/Y _8279_/Y VPWR VGND sg13g2_o21ai_1
X_4512_ _4512_/Y _6309_/A _4512_/B _8496_/A VPWR VGND sg13g2_nor3_1
X_5492_ _6803_/B _5492_/A _6804_/C _5492_/C _6804_/B VPWR VGND sg13g2_nor4_1
X_7300_ _7304_/C _7294_/Y _7299_/Y _7512_/B1 VPWR VGND sg13g2_o21ai_1
X_7231_ _8892_/D _7230_/Y _8892_/Q _7239_/S VPWR VGND sg13g2_mux2_1
XFILLER_8_693 VPWR VGND sg13g2_decap_8
X_4443_ _4447_/C _4443_/A _4443_/B VPWR VGND sg13g2_nand2_1
X_4374_ _8713_/D _9655_/D VPWR VGND sg13g2_inv_1
XFILLER_98_431 VPWR VGND sg13g2_decap_8
X_7162_ _7162_/Y _7162_/A _7172_/B _7207_/C _7179_/D VPWR VGND sg13g2_nand4_1
X_6113_ _6113_/Y _6090_/A _6171_/C _6161_/A VPWR VGND sg13g2_o21ai_1
X_7093_ _7093_/Y _7194_/B _7207_/B _7105_/C VPWR VGND sg13g2_nand3_1
XFILLER_98_497 VPWR VGND sg13g2_fill_2
X_9591__2799 _9591_/RESET_B VPWR VGND sg13g2_tiehi
X_6044_ _6309_/B _6044_/A _6410_/C _6044_/C VPWR VGND sg13g2_nand3_1
XFILLER_26_203 VPWR VGND sg13g2_fill_1
XFILLER_94_692 VPWR VGND sg13g2_decap_4
XFILLER_81_331 VPWR VGND sg13g2_decap_8
XFILLER_66_383 VPWR VGND sg13g2_fill_2
XFILLER_39_597 VPWR VGND sg13g2_decap_8
X_7995_ _7995_/Y _8019_/A _9008_/Q _8411_/C VPWR VGND sg13g2_nand3_1
X_6946_ _6946_/Y _6737_/Y _6739_/Y _6945_/Y VPWR VGND sg13g2_o21ai_1
XFILLER_35_770 VPWR VGND sg13g2_fill_1
XFILLER_35_781 VPWR VGND sg13g2_fill_1
X_6877_ _6877_/X _8912_/Q _8944_/Q _6877_/S VPWR VGND sg13g2_mux2_1
X_9665_ _9665_/Q _9672_/CLK _9665_/D place2440/X VPWR VGND sg13g2_dfrbpq_1
X_5828_ _5828_/Y _8750_/Q _8520_/C _7775_/D _5828_/D VPWR VGND sg13g2_nor4_1
X_9596_ _9596_/Q _9620_/CLK _9596_/D _9596_/RESET_B VPWR VGND sg13g2_dfrbpq_1
XFILLER_10_604 VPWR VGND sg13g2_fill_2
X_8616_ _8616_/Q _9689_/CLK _8616_/D fanout949/X VPWR VGND sg13g2_dfrbpq_1
X_8547_ _9266_/D _8547_/A VPWR VGND sg13g2_inv_1
X_5759_ _5759_/Y _5771_/A1 _9310_/Q _5771_/B1 VPWR VGND sg13g2_a21oi_1
XFILLER_22_497 VPWR VGND sg13g2_decap_8
XFILLER_108_503 VPWR VGND sg13g2_fill_2
XFILLER_118_21 VPWR VGND sg13g2_decap_8
X_9526__2854 _9526_/RESET_B VPWR VGND sg13g2_tiehi
XFILLER_108_569 VPWR VGND sg13g2_decap_8
X_8478_ _8478_/Y _8490_/A _9244_/Q _8490_/C VPWR VGND sg13g2_nand3_1
Xplace2082 _5954_/A _5945_/A VPWR VGND sg13g2_buf_1
Xplace2060 _6672_/C _6588_/C VPWR VGND sg13g2_buf_1
Xplace2071 _5360_/D _6994_/D VPWR VGND sg13g2_buf_1
X_7429_ _7429_/Y _7489_/A _7429_/B _7429_/C _7429_/D VPWR VGND sg13g2_nor4_1
XFILLER_123_539 VPWR VGND sg13g2_decap_8
XFILLER_118_87 VPWR VGND sg13g2_fill_1
XFILLER_118_76 VPWR VGND sg13g2_decap_8
XFILLER_116_580 VPWR VGND sg13g2_decap_8
Xplace2093 _5930_/A2 _5906_/A2 VPWR VGND sg13g2_buf_1
XFILLER_104_775 VPWR VGND sg13g2_decap_8
XFILLER_89_442 VPWR VGND sg13g2_decap_8
XFILLER_104_786 VPWR VGND sg13g2_fill_1
XFILLER_103_274 VPWR VGND sg13g2_fill_2
XFILLER_92_629 VPWR VGND sg13g2_decap_8
XFILLER_91_117 VPWR VGND sg13g2_fill_1
XFILLER_57_394 VPWR VGND sg13g2_fill_2
XFILLER_40_250 VPWR VGND sg13g2_decap_4
XFILLER_41_762 VPWR VGND sg13g2_decap_8
XFILLER_9_457 VPWR VGND sg13g2_decap_8
XFILLER_13_497 VPWR VGND sg13g2_decap_4
XFILLER_9_479 VPWR VGND sg13g2_fill_2
XFILLER_114_517 VPWR VGND sg13g2_decap_4
XFILLER_4_151 VPWR VGND sg13g2_fill_2
XFILLER_122_550 VPWR VGND sg13g2_decap_4
XFILLER_4_77 VPWR VGND sg13g2_fill_1
XFILLER_4_66 VPWR VGND sg13g2_decap_8
XFILLER_67_136 VPWR VGND sg13g2_decap_8
XFILLER_83_629 VPWR VGND sg13g2_decap_8
XFILLER_76_692 VPWR VGND sg13g2_decap_8
XFILLER_63_320 VPWR VGND sg13g2_fill_1
X_6800_ _6800_/Y _4714_/C _4712_/X _6800_/B1 VPWR VGND sg13g2_o21ai_1
XFILLER_36_556 VPWR VGND sg13g2_decap_8
X_9576__2814 _9576_/RESET_B VPWR VGND sg13g2_tiehi
X_7780_ _7780_/Y _7780_/A _7780_/B _7780_/C _7780_/D VPWR VGND sg13g2_nor4_1
X_4992_ _4992_/Y _9403_/Q _4934_/B _4991_/Y VPWR VGND sg13g2_a21oi_1
X_6731_ _9499_/D _9540_/Q _9499_/Q _6736_/S VPWR VGND sg13g2_mux2_1
XFILLER_23_239 VPWR VGND sg13g2_fill_2
X_6662_ _6662_/Y _8652_/Q _6666_/A2 _6661_/X VPWR VGND sg13g2_o21ai_1
X_9450_ _9450_/Q _9567_/CLK _9450_/D fanout981/X VPWR VGND sg13g2_dfrbpq_1
X_8401_ _8401_/Y _8401_/A _9201_/Q _8401_/C VPWR VGND sg13g2_nand3_1
X_9381_ _9381_/Q _9414_/CLK _9381_/D place2501/X VPWR VGND sg13g2_dfrbpq_1
X_5613_ _5613_/Y _8660_/Q _5498_/X _5500_/Y _8659_/Q VPWR VGND sg13g2_a22oi_1
X_6593_ _9429_/D _6670_/A1 _6592_/Y _6591_/Y VPWR VGND sg13g2_o21ai_1
X_8332_ _9166_/D _8344_/A1 _8077_/Y _8331_/Y VPWR VGND sg13g2_o21ai_1
XFILLER_117_344 VPWR VGND sg13g2_decap_4
X_5544_ _5544_/Y _9434_/Q _5591_/B _5589_/B1 _8636_/Q VPWR VGND sg13g2_a22oi_1
X_8263_ _8263_/Y _8263_/A _8287_/B VPWR VGND sg13g2_nand2_1
X_5475_ _5476_/A _4387_/Y _8696_/Q _5423_/B _4388_/X VPWR VGND sg13g2_a22oi_1
X_7214_ _7214_/Y _7236_/A _7214_/B _8496_/B _7236_/D VPWR VGND sg13g2_nand4_1
X_4426_ _6190_/D _9244_/Q _9243_/Q VPWR VGND sg13g2_nor2_1
X_8194_ _9097_/D _5836_/D _7920_/Y _8193_/Y VPWR VGND sg13g2_o21ai_1
X_7145_ _8867_/D _6975_/X _7143_/Y _7144_/Y VPWR VGND sg13g2_o21ai_1
XFILLER_101_712 VPWR VGND sg13g2_decap_8
XFILLER_99_795 VPWR VGND sg13g2_fill_2
X_4357_ _4358_/B _9207_/Q _9684_/Q _9687_/Q _4618_/B VPWR VGND sg13g2_nor4_1
XFILLER_58_136 VPWR VGND sg13g2_fill_1
X_7076_ _8845_/D _7075_/Y _8845_/Q _7085_/S VPWR VGND sg13g2_mux2_1
XFILLER_100_266 VPWR VGND sg13g2_fill_2
X_6027_ _6338_/C _6338_/B _6033_/C _6033_/D _6049_/A VPWR VGND sg13g2_nor4_1
XFILLER_64_27 VPWR VGND sg13g2_decap_4
XFILLER_54_320 VPWR VGND sg13g2_fill_2
XFILLER_27_523 VPWR VGND sg13g2_fill_2
XFILLER_70_802 VPWR VGND sg13g2_fill_2
XFILLER_54_353 VPWR VGND sg13g2_fill_1
XFILLER_82_684 VPWR VGND sg13g2_decap_8
XFILLER_15_729 VPWR VGND sg13g2_decap_4
X_7978_ _8999_/D _5353_/C _7985_/A _7977_/Y VPWR VGND sg13g2_o21ai_1
X_6929_ _9628_/D _6927_/Y _6928_/Y _6926_/Y VPWR VGND sg13g2_o21ai_1
X_9648_ _9648_/Q _9649_/CLK _9648_/D fanout973/X VPWR VGND sg13g2_dfrbpq_1
XFILLER_23_762 VPWR VGND sg13g2_decap_4
XFILLER_13_42 VPWR VGND sg13g2_fill_1
X_9579_ _9579_/Q _9582_/CLK _9579_/D _9579_/RESET_B VPWR VGND sg13g2_dfrbpq_1
XFILLER_108_300 VPWR VGND sg13g2_decap_8
XFILLER_89_35 VPWR VGND sg13g2_decap_8
XFILLER_2_600 VPWR VGND sg13g2_fill_1
XFILLER_2_677 VPWR VGND sg13g2_fill_2
Xfanout970 fanout970/X fanout972/X VPWR VGND sg13g2_buf_1
Xfanout981 fanout981/X fanout982/X VPWR VGND sg13g2_buf_1
XFILLER_92_404 VPWR VGND sg13g2_fill_1
XFILLER_18_534 VPWR VGND sg13g2_fill_1
XFILLER_73_640 VPWR VGND sg13g2_fill_2
XFILLER_45_364 VPWR VGND sg13g2_decap_8
XFILLER_45_375 VPWR VGND sg13g2_fill_1
XFILLER_60_345 VPWR VGND sg13g2_decap_8
XFILLER_54_82 VPWR VGND sg13g2_fill_2
XFILLER_54_71 VPWR VGND sg13g2_decap_8
Xclkload35 clkload35/Y _9449_/CLK VPWR VGND sg13g2_inv_4
Xclkload24 clkload24/X _9611_/CLK VPWR VGND sg13g2_buf_8
Xclkload13 clkload13/Y _9254_/CLK VPWR VGND sg13g2_inv_4
XFILLER_9_287 VPWR VGND sg13g2_fill_2
X_5260_ _5286_/B _9873_/A _5280_/A _5260_/C _5291_/C VPWR VGND sg13g2_and4_1
XFILLER_79_90 VPWR VGND sg13g2_decap_8
X_5191_ _5191_/Y _5191_/A _5191_/B _5191_/C VPWR VGND sg13g2_nor3_1
XFILLER_96_743 VPWR VGND sg13g2_decap_8
X_8950_ _8950_/Q _9615_/CLK _8950_/D place2417/X VPWR VGND sg13g2_dfrbpq_1
XFILLER_96_798 VPWR VGND sg13g2_fill_2
XFILLER_68_478 VPWR VGND sg13g2_decap_8
X_7901_ _7901_/Y _7904_/A _8965_/Q _8365_/C VPWR VGND sg13g2_nand3_1
XFILLER_83_459 VPWR VGND sg13g2_decap_8
X_8881_ _8881_/Q _9252_/CLK _8881_/D place2426/X VPWR VGND sg13g2_dfrbpq_1
XFILLER_64_640 VPWR VGND sg13g2_fill_1
XFILLER_51_312 VPWR VGND sg13g2_decap_8
XFILLER_24_537 VPWR VGND sg13g2_decap_8
X_7832_ _7836_/A _7834_/A _9144_/Q _7832_/C VPWR VGND sg13g2_nor3_1
X_7763_ _7763_/Y _7801_/A _7763_/B _7763_/C _7763_/D VPWR VGND sg13g2_nor4_1
XFILLER_36_397 VPWR VGND sg13g2_decap_4
X_4975_ _4977_/A _4994_/A _9369_/Q VPWR VGND sg13g2_nor2b_1
X_6714_ _9482_/D _9523_/Q _9482_/Q _6714_/S VPWR VGND sg13g2_mux2_1
X_9502_ _9502_/Q _9504_/CLK _9502_/D _9502_/RESET_B VPWR VGND sg13g2_dfrbpq_1
X_9433_ _9433_/Q _9645_/CLK _9433_/D fanout981/X VPWR VGND sg13g2_dfrbpq_1
X_7694_ _7696_/C _9880_/A _7694_/B VPWR VGND sg13g2_nand2_1
XFILLER_20_732 VPWR VGND sg13g2_fill_2
XFILLER_32_592 VPWR VGND sg13g2_decap_8
X_6645_ _6645_/Y _9445_/Q _6651_/B VPWR VGND sg13g2_nand2_1
Xclkbuf_leaf_17_clk_i _9260_/CLK clkbuf_3_6__f_clk_i/X VPWR VGND sg13g2_buf_16
Xclkload7 clkload7/Y clkload7/A VPWR VGND sg13g2_inv_1
XFILLER_20_765 VPWR VGND sg13g2_fill_1
X_6576_ _9424_/D _6670_/A1 _6575_/Y _6574_/Y VPWR VGND sg13g2_o21ai_1
XFILLER_20_798 VPWR VGND sg13g2_fill_2
X_9364_ _9364_/Q clkload9/A _9364_/D place2490/X VPWR VGND sg13g2_dfrbpq_1
X_9295_ _9295_/Q _9410_/CLK _9295_/D place2398/X VPWR VGND sg13g2_dfrbpq_1
X_5527_ _8630_/D _5526_/Y _5525_/Y _5602_/B1 VPWR VGND sg13g2_a21oi_1
X_8315_ _8315_/Y _8315_/A _8347_/B VPWR VGND sg13g2_nand2_1
XFILLER_105_336 VPWR VGND sg13g2_fill_1
X_8246_ _9123_/D _8252_/A1 _7909_/Y _8245_/Y VPWR VGND sg13g2_o21ai_1
Xoutput2683 master_addr_o[2] _9860_/X VPWR VGND sg13g2_buf_1
Xoutput2672 master_addr_o[1] _9859_/X VPWR VGND sg13g2_buf_1
Xoutput2661 master_addr_o[0] _9858_/X VPWR VGND sg13g2_buf_1
X_5458_ _8687_/D _5458_/A _5468_/B_N VPWR VGND sg13g2_nor2b_1
XFILLER_99_570 VPWR VGND sg13g2_decap_8
X_5389_ _5390_/B _6523_/A _5388_/Y _8520_/D _5379_/X _5386_/Y VPWR VGND sg13g2_a221oi_1
Xoutput2694 master_be_o[1] _5048_/Y VPWR VGND sg13g2_buf_1
XFILLER_59_412 VPWR VGND sg13g2_fill_2
X_4409_ _8665_/D _4409_/A _6737_/C VPWR VGND sg13g2_nor2b_1
X_8177_ _8177_/Y _8177_/A _8197_/B VPWR VGND sg13g2_nand2_1
XFILLER_101_531 VPWR VGND sg13g2_decap_8
XFILLER_86_231 VPWR VGND sg13g2_fill_1
X_7128_ _8862_/D _7127_/Y _8862_/Q _7131_/S VPWR VGND sg13g2_mux2_1
XFILLER_74_415 VPWR VGND sg13g2_decap_8
X_7059_ _7059_/Y _7059_/A _8840_/Q VPWR VGND sg13g2_nand2_1
XFILLER_101_597 VPWR VGND sg13g2_decap_8
XFILLER_39_191 VPWR VGND sg13g2_fill_2
XFILLER_70_610 VPWR VGND sg13g2_decap_8
XFILLER_55_695 VPWR VGND sg13g2_decap_8
XFILLER_70_643 VPWR VGND sg13g2_fill_2
XFILLER_15_537 VPWR VGND sg13g2_fill_1
XFILLER_24_41 VPWR VGND sg13g2_decap_4
XFILLER_11_776 VPWR VGND sg13g2_fill_1
XFILLER_7_703 VPWR VGND sg13g2_fill_2
XFILLER_109_642 VPWR VGND sg13g2_decap_8
XFILLER_11_787 VPWR VGND sg13g2_fill_2
XFILLER_108_152 VPWR VGND sg13g2_fill_1
XFILLER_108_141 VPWR VGND sg13g2_decap_8
XFILLER_40_95 VPWR VGND sg13g2_fill_1
XFILLER_123_133 VPWR VGND sg13g2_decap_8
XFILLER_97_507 VPWR VGND sg13g2_decap_8
XFILLER_2_463 VPWR VGND sg13g2_decap_8
XFILLER_93_724 VPWR VGND sg13g2_fill_1
XFILLER_78_787 VPWR VGND sg13g2_fill_1
XFILLER_78_765 VPWR VGND sg13g2_fill_1
XFILLER_1_56 VPWR VGND sg13g2_decap_4
XFILLER_92_234 VPWR VGND sg13g2_decap_8
XFILLER_52_109 VPWR VGND sg13g2_decap_8
XFILLER_46_684 VPWR VGND sg13g2_decap_8
XFILLER_33_323 VPWR VGND sg13g2_decap_4
XFILLER_60_142 VPWR VGND sg13g2_decap_8
X_4760_ _4791_/B _4820_/B _4923_/A VPWR VGND sg13g2_nor2_1
X_4691_ _4691_/X _4694_/A _4693_/B VPWR VGND sg13g2_or2_1
X_6430_ _6431_/B _8882_/Q _6462_/A2 _6429_/X _6430_/B2 VPWR VGND sg13g2_a22oi_1
Xplace1903 _6504_/A1 _6512_/A1 VPWR VGND sg13g2_buf_1
X_6361_ _9380_/D _9380_/Q _6392_/S _6360_/Y VPWR VGND sg13g2_a21o_1
X_5312_ _5317_/A _5311_/Y _5315_/B _7775_/B VPWR VGND sg13g2_o21ai_1
Xplace1914 _5375_/A _8563_/B VPWR VGND sg13g2_buf_1
Xplace1936 _7825_/B1 _7809_/B1 VPWR VGND sg13g2_buf_1
Xplace1925 _6512_/A2 _6470_/A2 VPWR VGND sg13g2_buf_1
X_8100_ _9050_/D _8100_/A1 _7954_/Y _8099_/Y VPWR VGND sg13g2_o21ai_1
Xplace1969 _7843_/B1 _5828_/Y VPWR VGND sg13g2_buf_1
X_9080_ _9080_/Q _9199_/CLK _9080_/D place2427/X VPWR VGND sg13g2_dfrbpq_1
Xplace1958 _6434_/A2 _6515_/B1 VPWR VGND sg13g2_buf_1
Xplace1947 _6188_/A _6369_/B VPWR VGND sg13g2_buf_1
X_6292_ _6292_/Y _9245_/Q _6323_/C _6332_/B _6332_/C VPWR VGND sg13g2_nand4_1
X_5243_ _5244_/B _5272_/A _5243_/B _5280_/B _9874_/A VPWR VGND sg13g2_nand4_1
X_8031_ _8031_/Y _8031_/A _8099_/B VPWR VGND sg13g2_nand2_1
XFILLER_96_540 VPWR VGND sg13g2_fill_2
X_5174_ _5181_/A _5157_/Y _5167_/Y _5188_/A VPWR VGND sg13g2_o21ai_1
XFILLER_96_573 VPWR VGND sg13g2_fill_1
XFILLER_84_713 VPWR VGND sg13g2_fill_2
XFILLER_56_415 VPWR VGND sg13g2_decap_8
X_8933_ _8933_/Q _9198_/CLK _8933_/D place2452/X VPWR VGND sg13g2_dfrbpq_1
XFILLER_56_459 VPWR VGND sg13g2_decap_8
XFILLER_45_18 VPWR VGND sg13g2_fill_2
X_8864_ _8864_/Q _9692_/CLK _8864_/D place2496/X VPWR VGND sg13g2_dfrbpq_1
XFILLER_64_492 VPWR VGND sg13g2_decap_8
X_7815_ _7817_/B _9205_/Q _7815_/B VPWR VGND sg13g2_nor2_1
XFILLER_101_35 VPWR VGND sg13g2_decap_8
X_8795_ _8795_/Q _9252_/CLK _8795_/D place2403/X VPWR VGND sg13g2_dfrbpq_1
X_7746_ _7749_/A _7747_/A _7803_/B _9108_/Q VPWR VGND sg13g2_nor3_1
X_4958_ _4960_/C _9398_/Q _4972_/B VPWR VGND sg13g2_nand2_1
X_7677_ _7677_/Y _7829_/A _7676_/Y VPWR VGND sg13g2_nor2b_1
Xinput2559 _7789_/B2 hartinfo_i[27] VPWR VGND sg13g2_buf_1
Xinput2548 _7580_/B2 hartinfo_i[17] VPWR VGND sg13g2_buf_1
X_4889_ _4889_/Y _4842_/A _4776_/B _4820_/B VPWR VGND sg13g2_a21oi_1
X_6628_ _6628_/Y _6628_/A _6651_/B VPWR VGND sg13g2_nand2_1
XFILLER_20_584 VPWR VGND sg13g2_decap_8
X_9416_ _9416_/Q _9701_/CLK _9416_/D fanout957/X VPWR VGND sg13g2_dfrbpq_1
X_9347_ _9347_/Q _9414_/CLK _9347_/D place2502/X VPWR VGND sg13g2_dfrbpq_1
XFILLER_10_21 VPWR VGND sg13g2_decap_8
XFILLER_4_739 VPWR VGND sg13g2_decap_4
XFILLER_3_216 VPWR VGND sg13g2_decap_8
X_6559_ _9421_/D _8662_/Q _6544_/Y _6558_/X VPWR VGND sg13g2_a21o_1
X_9278_ _9278_/Q _9305_/CLK _9278_/D place2405/X VPWR VGND sg13g2_dfrbpq_1
XFILLER_79_518 VPWR VGND sg13g2_fill_1
X_8229_ _8229_/Y _8229_/A _8251_/B VPWR VGND sg13g2_nand2_1
XFILLER_120_158 VPWR VGND sg13g2_fill_2
XFILLER_47_404 VPWR VGND sg13g2_fill_2
XFILLER_101_372 VPWR VGND sg13g2_decap_8
XFILLER_101_361 VPWR VGND sg13g2_fill_1
XFILLER_75_724 VPWR VGND sg13g2_decap_8
XFILLER_74_223 VPWR VGND sg13g2_fill_1
XFILLER_75_768 VPWR VGND sg13g2_decap_4
XFILLER_74_234 VPWR VGND sg13g2_decap_8
XFILLER_47_448 VPWR VGND sg13g2_fill_1
XFILLER_90_727 VPWR VGND sg13g2_decap_8
XFILLER_34_109 VPWR VGND sg13g2_decap_8
XFILLER_15_356 VPWR VGND sg13g2_decap_8
XFILLER_42_131 VPWR VGND sg13g2_decap_8
XFILLER_70_495 VPWR VGND sg13g2_decap_8
XFILLER_11_540 VPWR VGND sg13g2_fill_2
XFILLER_51_61 VPWR VGND sg13g2_decap_8
XFILLER_51_94 VPWR VGND sg13g2_fill_2
XFILLER_112_626 VPWR VGND sg13g2_decap_8
X_9539__2841 _9539_/RESET_B VPWR VGND sg13g2_tiehi
XFILLER_78_551 VPWR VGND sg13g2_decap_8
XFILLER_66_702 VPWR VGND sg13g2_decap_8
XFILLER_38_437 VPWR VGND sg13g2_decap_8
X_5930_ _5930_/Y _5930_/A1 _5930_/A2 _5929_/Y VPWR VGND sg13g2_a21oi_1
XFILLER_18_161 VPWR VGND sg13g2_fill_2
XFILLER_46_481 VPWR VGND sg13g2_decap_4
XFILLER_46_492 VPWR VGND sg13g2_decap_8
X_5861_ _5861_/X _5858_/Y _5859_/Y _5860_/Y VPWR VGND sg13g2_a21o_1
X_7600_ _7600_/Y _7600_/A _7600_/B VPWR VGND sg13g2_nand2_1
X_8580_ _9282_/D _8580_/A VPWR VGND sg13g2_inv_1
X_5792_ _5793_/A _9289_/Q _5786_/Y _5787_/Y _9486_/Q VPWR VGND sg13g2_a22oi_1
XFILLER_61_473 VPWR VGND sg13g2_fill_1
XFILLER_21_304 VPWR VGND sg13g2_decap_4
XFILLER_21_315 VPWR VGND sg13g2_fill_2
XFILLER_21_337 VPWR VGND sg13g2_decap_8
X_4812_ _4812_/Y _4813_/A _4816_/B VPWR VGND sg13g2_nor2_1
X_4743_ _9706_/D _4743_/A _4743_/B VPWR VGND sg13g2_nor2_1
X_7531_ _7534_/B _7525_/Y _7530_/Y _8056_/D VPWR VGND sg13g2_o21ai_1
X_7462_ _7466_/D _9187_/Q _7485_/B _7822_/A VPWR VGND sg13g2_o21ai_1
X_4674_ _6690_/S _4675_/A _4674_/B _4674_/C VPWR VGND sg13g2_nor3_1
Xplace2412 place2412/X place2413/X VPWR VGND sg13g2_buf_1
Xplace2401 place2401/X place2454/X VPWR VGND sg13g2_buf_1
X_9201_ _9201_/Q clkload7/A _9201_/D place2457/X VPWR VGND sg13g2_dfrbpq_1
X_6413_ _6413_/X _9004_/Q _9066_/Q _9128_/Q _9190_/Q _6421_/S0 _6421_/S1 VPWR VGND
+ sg13g2_mux4_1
Xplace2445 place2445/X place2446/X VPWR VGND sg13g2_buf_1
X_7393_ _7395_/C _9281_/Q _7557_/A2 _7557_/B1 _9313_/Q VPWR VGND sg13g2_a22oi_1
Xplace2423 place2423/X place2425/X VPWR VGND sg13g2_buf_1
Xplace2434 place2434/X place2435/X VPWR VGND sg13g2_buf_1
Xplace2456 place2456/X place2459/X VPWR VGND sg13g2_buf_1
X_9132_ _9132_/Q clkload6/A _9132_/D place2435/X VPWR VGND sg13g2_dfrbpq_1
Xplace2489 place2489/X place2507/X VPWR VGND sg13g2_buf_1
X_6344_ _6347_/A _6042_/C _6343_/X _6338_/Y VPWR VGND sg13g2_o21ai_1
Xplace2467 place2467/X place2476/X VPWR VGND sg13g2_buf_1
Xplace2478 place2478/X place2479/X VPWR VGND sg13g2_buf_1
Xplace1777 _6660_/B _6671_/B VPWR VGND sg13g2_buf_1
Xhold3103 _8337_/A _9169_/Q VPWR VGND sg13g2_dlygate4sd3_1
Xhold3114 _8121_/A _9061_/Q VPWR VGND sg13g2_dlygate4sd3_1
X_9063_ _9063_/Q _9188_/CLK _9063_/D place2474/X VPWR VGND sg13g2_dfrbpq_1
X_6275_ _6287_/B _6309_/A _6275_/B VPWR VGND sg13g2_nand2_1
Xhold3158 _6610_/A _9435_/Q VPWR VGND sg13g2_dlygate4sd3_1
Xhold3125 _8261_/A _9131_/Q VPWR VGND sg13g2_dlygate4sd3_1
Xhold3136 _8279_/A _9140_/Q VPWR VGND sg13g2_dlygate4sd3_1
Xhold3147 _8341_/A _9171_/Q VPWR VGND sg13g2_dlygate4sd3_1
Xplace1799 _5341_/A1 _5288_/A1 VPWR VGND sg13g2_buf_1
Xplace1788 _8285_/B _8279_/B VPWR VGND sg13g2_buf_1
X_5226_ _5358_/C _8414_/C _9485_/Q VPWR VGND sg13g2_nand2_1
X_8014_ _9017_/D _5371_/C _8017_/A _8013_/Y VPWR VGND sg13g2_o21ai_1
XFILLER_69_562 VPWR VGND sg13g2_fill_1
Xhold3169 _8289_/A _9145_/Q VPWR VGND sg13g2_dlygate4sd3_1
X_5157_ _5157_/Y _5158_/D _5187_/C _9864_/A VPWR VGND sg13g2_a21oi_1
XFILLER_69_595 VPWR VGND sg13g2_fill_1
XFILLER_57_724 VPWR VGND sg13g2_fill_1
X_5088_ _5090_/A _5051_/Y _5736_/A _5065_/D VPWR VGND sg13g2_a21oi_1
XFILLER_84_532 VPWR VGND sg13g2_decap_8
X_8916_ _8916_/Q _9615_/CLK _8916_/D place2417/X VPWR VGND sg13g2_dfrbpq_1
XFILLER_112_34 VPWR VGND sg13g2_fill_1
XFILLER_37_481 VPWR VGND sg13g2_fill_2
XFILLER_112_78 VPWR VGND sg13g2_decap_8
XFILLER_24_153 VPWR VGND sg13g2_decap_8
XFILLER_40_602 VPWR VGND sg13g2_decap_4
X_8847_ _8847_/Q _9251_/CLK _8847_/D place2463/X VPWR VGND sg13g2_dfrbpq_1
X_8778_ _9884_/A _9260_/CLK _8778_/D place2394/X VPWR VGND sg13g2_dfrbpq_1
X_7729_ _7729_/Y _7775_/A _7729_/B _7775_/C _7775_/D VPWR VGND sg13g2_nor4_1
X_9589__2801 _9589_/RESET_B VPWR VGND sg13g2_tiehi
XFILLER_21_75 VPWR VGND sg13g2_fill_1
XFILLER_121_467 VPWR VGND sg13g2_decap_4
XFILLER_102_681 VPWR VGND sg13g2_fill_1
XFILLER_48_713 VPWR VGND sg13g2_fill_2
Xhold2991 _9654_/D _4567_/Y VPWR VGND sg13g2_dlygate4sd3_1
XFILLER_101_180 VPWR VGND sg13g2_fill_2
XFILLER_75_543 VPWR VGND sg13g2_decap_8
Xhold2980 _6387_/B1 _9385_/Q VPWR VGND sg13g2_dlygate4sd3_1
XFILLER_75_598 VPWR VGND sg13g2_decap_8
XFILLER_62_237 VPWR VGND sg13g2_fill_1
XFILLER_46_83 VPWR VGND sg13g2_decap_4
XFILLER_16_665 VPWR VGND sg13g2_fill_2
XFILLER_71_782 VPWR VGND sg13g2_decap_8
XFILLER_30_112 VPWR VGND sg13g2_fill_2
XFILLER_31_657 VPWR VGND sg13g2_decap_8
XFILLER_117_718 VPWR VGND sg13g2_decap_8
XFILLER_109_280 VPWR VGND sg13g2_decap_8
X_4390_ _4390_/Y _8677_/Q _5434_/B VPWR VGND sg13g2_nor2_1
XFILLER_98_602 VPWR VGND sg13g2_fill_1
XFILLER_112_423 VPWR VGND sg13g2_decap_4
XFILLER_112_456 VPWR VGND sg13g2_fill_1
XFILLER_112_445 VPWR VGND sg13g2_decap_8
XFILLER_97_167 VPWR VGND sg13g2_fill_1
X_6060_ _6438_/B _6158_/A _6224_/A VPWR VGND sg13g2_nand2b_1
X_5011_ _5011_/Y _4798_/Y _5010_/Y _5008_/Y VPWR VGND sg13g2_a21oi_1
XFILLER_66_554 VPWR VGND sg13g2_fill_1
X_6962_ _6962_/Y _8820_/D _6962_/B _9221_/D _6962_/D VPWR VGND sg13g2_nand4_1
X_6893_ _6893_/X _8920_/Q _8952_/Q _6901_/S VPWR VGND sg13g2_mux2_1
X_5913_ _5913_/Y _5913_/A _5929_/B VPWR VGND sg13g2_nor2_1
X_8701_ _8701_/Q _9675_/CLK _9546_/Q place2444/X VPWR VGND sg13g2_dfrbpq_1
XFILLER_62_760 VPWR VGND sg13g2_decap_8
X_9681_ _9681_/Q _9689_/CLK _9681_/D fanout962/X VPWR VGND sg13g2_dfrbpq_1
X_5844_ _5844_/Y _5844_/A _5954_/C VPWR VGND sg13g2_nor2b_1
X_8632_ _8632_/Q _9645_/CLK _8632_/D fanout970/X VPWR VGND sg13g2_dfrbpq_1
X_8563_ _8563_/X _8563_/A _8563_/B _8563_/C _8563_/D VPWR VGND sg13g2_or4_1
X_5775_ _5775_/X _9316_/Q _9332_/Q _9308_/Q _9324_/Q _5050_/Y _5085_/Y VPWR VGND sg13g2_mux4_1
X_7514_ _7515_/C _8846_/Q _7598_/A2 _7598_/B1 _8877_/Q VPWR VGND sg13g2_a22oi_1
X_8494_ _8494_/Y _8494_/A _8494_/B _9221_/D VPWR VGND sg13g2_nand3_1
X_4726_ _9686_/D _4726_/A _4726_/B VPWR VGND sg13g2_nor2_1
X_4657_ _4658_/B _9642_/Q _6953_/S VPWR VGND sg13g2_nor2_1
Xplace2220 _7245_/A _9469_/Q VPWR VGND sg13g2_buf_1
X_7445_ _7448_/A _9186_/Q _7485_/B VPWR VGND sg13g2_nor2_1
Xplace2231 _7667_/A _7431_/A VPWR VGND sg13g2_buf_1
X_7376_ _7376_/Y _7376_/A _7376_/B _7376_/C VPWR VGND sg13g2_nand3_1
Xplace2253 _7486_/A _7492_/A VPWR VGND sg13g2_buf_1
Xplace2242 _7834_/A _9465_/Q VPWR VGND sg13g2_buf_1
Xplace2264 _7839_/B _7608_/B VPWR VGND sg13g2_buf_1
XFILLER_116_784 VPWR VGND sg13g2_fill_2
X_9115_ _9115_/Q clkload5/A _9115_/D place2499/X VPWR VGND sg13g2_dfrbpq_1
Xplace2286 _4903_/A _9342_/Q VPWR VGND sg13g2_buf_1
X_4588_ _4588_/Y _6939_/C _4589_/C VPWR VGND sg13g2_nand2_1
Xplace2297 _4928_/B _4827_/B VPWR VGND sg13g2_buf_1
Xplace2275 _7608_/B _7834_/B VPWR VGND sg13g2_buf_1
X_6327_ _6328_/B _8863_/Q _6496_/A2 _6326_/X _6422_/B1 _6309_/Y VPWR VGND sg13g2_a221oi_1
XFILLER_89_635 VPWR VGND sg13g2_decap_4
XFILLER_76_307 VPWR VGND sg13g2_fill_1
X_9046_ _9046_/Q _9198_/CLK _9046_/D place2437/X VPWR VGND sg13g2_dfrbpq_1
XFILLER_67_27 VPWR VGND sg13g2_decap_8
X_6258_ _6260_/A _6189_/C _6509_/D _6438_/A _6323_/C VPWR VGND sg13g2_a22oi_1
XFILLER_97_690 VPWR VGND sg13g2_decap_8
XFILLER_88_178 VPWR VGND sg13g2_decap_4
X_5209_ _5355_/C _8448_/C _9482_/Q VPWR VGND sg13g2_nand2_1
X_6189_ _6189_/X _6262_/B _6451_/B _6189_/C _6189_/D VPWR VGND sg13g2_or4_1
X_9480__2900 _9480_/RESET_B VPWR VGND sg13g2_tiehi
XFILLER_69_392 VPWR VGND sg13g2_fill_2
XFILLER_123_77 VPWR VGND sg13g2_decap_8
XFILLER_45_727 VPWR VGND sg13g2_decap_8
XFILLER_45_738 VPWR VGND sg13g2_fill_1
X_9879_ _9879_/X _9879_/A VPWR VGND sg13g2_buf_1
XFILLER_53_760 VPWR VGND sg13g2_fill_1
XFILLER_25_451 VPWR VGND sg13g2_fill_2
XFILLER_80_590 VPWR VGND sg13g2_fill_1
XFILLER_13_668 VPWR VGND sg13g2_decap_8
XFILLER_32_74 VPWR VGND sg13g2_fill_1
XFILLER_4_333 VPWR VGND sg13g2_decap_8
XFILLER_4_366 VPWR VGND sg13g2_decap_4
XFILLER_4_344 VPWR VGND sg13g2_fill_1
XFILLER_79_123 VPWR VGND sg13g2_fill_2
XFILLER_122_776 VPWR VGND sg13g2_decap_8
XFILLER_121_220 VPWR VGND sg13g2_fill_1
Xclkbuf_leaf_2_jtag_tck_i_regs _9689_/CLK clkbuf_leaf_6_jtag_tck_i_regs/A VPWR VGND
+ sg13g2_buf_16
XFILLER_79_189 VPWR VGND sg13g2_decap_8
XFILLER_79_178 VPWR VGND sg13g2_fill_1
XFILLER_48_554 VPWR VGND sg13g2_decap_8
XFILLER_0_594 VPWR VGND sg13g2_decap_4
XFILLER_75_362 VPWR VGND sg13g2_decap_8
XFILLER_63_502 VPWR VGND sg13g2_decap_8
XFILLER_90_310 VPWR VGND sg13g2_decap_8
XFILLER_63_557 VPWR VGND sg13g2_decap_8
XFILLER_43_270 VPWR VGND sg13g2_decap_4
X_9489__2891 _9489_/RESET_B VPWR VGND sg13g2_tiehi
XFILLER_16_495 VPWR VGND sg13g2_fill_2
XFILLER_43_292 VPWR VGND sg13g2_decap_8
XFILLER_31_487 VPWR VGND sg13g2_decap_8
X_5560_ _8641_/D _5559_/Y _5558_/Y _5581_/B1 VPWR VGND sg13g2_a21oi_1
X_4511_ _8496_/A _7735_/A _8515_/A _7735_/B _4523_/B VPWR VGND sg13g2_nand4_1
X_5491_ _6804_/C _9682_/Q _5491_/B _5491_/C _5491_/D VPWR VGND sg13g2_nand4_1
XFILLER_8_672 VPWR VGND sg13g2_decap_4
X_7230_ _7230_/Y _7238_/A1 _7228_/Y _7229_/Y VPWR VGND sg13g2_a21oi_1
X_4442_ _4443_/B _7204_/A _7201_/A _7210_/B _7207_/A VPWR VGND sg13g2_nor4_1
X_4373_ _9655_/D _6686_/B _4373_/B VPWR VGND sg13g2_nand2b_1
XFILLER_98_410 VPWR VGND sg13g2_fill_1
X_7161_ _8872_/D _7159_/Y _8872_/Q _7185_/S VPWR VGND sg13g2_mux2_1
X_7092_ _8850_/D _7091_/Y _8850_/Q _7110_/S VPWR VGND sg13g2_mux2_1
X_6112_ _6112_/Y _6373_/A1 _6373_/A2 _9349_/Q VPWR VGND sg13g2_a21oi_1
XFILLER_112_253 VPWR VGND sg13g2_decap_4
XFILLER_86_649 VPWR VGND sg13g2_decap_4
X_6043_ _6044_/C _6348_/D _6043_/B _6047_/A _6365_/A VPWR VGND sg13g2_nand4_1
XFILLER_100_459 VPWR VGND sg13g2_decap_8
XFILLER_85_148 VPWR VGND sg13g2_decap_4
XFILLER_39_565 VPWR VGND sg13g2_decap_8
X_7994_ _9007_/D _5361_/C _8011_/A _7993_/Y VPWR VGND sg13g2_o21ai_1
XFILLER_54_557 VPWR VGND sg13g2_fill_2
X_6945_ _6945_/Y _6945_/A _6945_/B _6945_/C _6951_/A VPWR VGND sg13g2_nand4_1
XFILLER_81_398 VPWR VGND sg13g2_fill_2
X_6876_ _9604_/D _6875_/X _9604_/Q _6902_/S VPWR VGND sg13g2_mux2_1
X_9664_ _9664_/Q _9672_/CLK _9664_/D place2440/X VPWR VGND sg13g2_dfrbpq_1
X_5827_ _5828_/D _5827_/A _7519_/C VPWR VGND sg13g2_nand2_1
X_9595_ _9595_/Q _9620_/CLK _9595_/D _9595_/RESET_B VPWR VGND sg13g2_dfrbpq_1
X_8615_ _8615_/Q _9689_/CLK _8615_/D fanout949/X VPWR VGND sg13g2_dfrbpq_1
X_8546_ _8547_/A _9266_/Q _8560_/A2 _8560_/B1 _9491_/Q VPWR VGND sg13g2_a22oi_1
X_5758_ _5758_/Y _9318_/Q _5769_/B _5757_/Y VPWR VGND sg13g2_o21ai_1
X_4709_ _4709_/Y _8740_/Q _9674_/Q _6955_/S _4703_/Y VPWR VGND sg13g2_a22oi_1
X_8477_ _9243_/D _8476_/A _5358_/C _8476_/Y VPWR VGND sg13g2_o21ai_1
XFILLER_108_537 VPWR VGND sg13g2_decap_8
X_5689_ _5690_/A _8599_/Q _5693_/A2 _5693_/B1 _5689_/B2 VPWR VGND sg13g2_a22oi_1
X_7428_ _7429_/D _9030_/Q _7491_/B _7425_/Y VPWR VGND sg13g2_o21ai_1
Xplace2072 _5375_/D _5373_/D VPWR VGND sg13g2_buf_1
Xplace2061 _6588_/C _5479_/Y VPWR VGND sg13g2_buf_1
Xplace2050 _5677_/A2 _5624_/X VPWR VGND sg13g2_buf_1
Xplace2083 _5945_/A _5952_/A VPWR VGND sg13g2_buf_1
Xplace2094 _5932_/B _5906_/A2 VPWR VGND sg13g2_buf_1
XFILLER_89_421 VPWR VGND sg13g2_decap_8
X_7359_ _7359_/Y _8869_/Q _7533_/B1 _6994_/Y _7359_/B2 _7358_/Y VPWR VGND sg13g2_a221oi_1
XFILLER_104_765 VPWR VGND sg13g2_decap_4
XFILLER_103_231 VPWR VGND sg13g2_fill_1
XFILLER_1_358 VPWR VGND sg13g2_fill_2
XFILLER_103_253 VPWR VGND sg13g2_decap_8
X_9029_ _9029_/Q _9183_/CLK _9029_/D place2471/X VPWR VGND sg13g2_dfrbpq_1
XFILLER_85_682 VPWR VGND sg13g2_fill_2
XFILLER_57_373 VPWR VGND sg13g2_decap_8
XFILLER_45_535 VPWR VGND sg13g2_fill_1
XFILLER_72_387 VPWR VGND sg13g2_fill_2
XFILLER_26_771 VPWR VGND sg13g2_decap_8
XFILLER_26_782 VPWR VGND sg13g2_fill_1
XFILLER_9_414 VPWR VGND sg13g2_decap_8
XFILLER_13_465 VPWR VGND sg13g2_fill_2
XFILLER_43_95 VPWR VGND sg13g2_fill_2
XFILLER_99_207 VPWR VGND sg13g2_fill_2
XFILLER_68_605 VPWR VGND sg13g2_decap_4
XFILLER_4_56 VPWR VGND sg13g2_decap_4
XFILLER_68_638 VPWR VGND sg13g2_decap_8
XFILLER_68_649 VPWR VGND sg13g2_fill_1
XFILLER_0_380 VPWR VGND sg13g2_decap_8
XFILLER_36_524 VPWR VGND sg13g2_decap_4
XFILLER_63_343 VPWR VGND sg13g2_fill_2
XFILLER_63_332 VPWR VGND sg13g2_decap_8
XFILLER_24_719 VPWR VGND sg13g2_fill_1
X_6730_ _9498_/D _9539_/Q _9498_/Q _6736_/S VPWR VGND sg13g2_mux2_1
X_4991_ _4991_/Y _4813_/A _4903_/D _4974_/C VPWR VGND sg13g2_a21oi_1
XFILLER_16_270 VPWR VGND sg13g2_decap_4
X_6661_ _6661_/X _6661_/A _9584_/Q _6661_/C VPWR VGND sg13g2_or3_1
XFILLER_31_240 VPWR VGND sg13g2_decap_4
X_6592_ _6592_/Y _6588_/C _8631_/Q _9563_/Q _6566_/Y VPWR VGND sg13g2_a22oi_1
X_8400_ _9200_/D _5368_/C _8401_/A _8399_/Y VPWR VGND sg13g2_o21ai_1
X_9380_ _9380_/Q _9414_/CLK _9380_/D place2501/X VPWR VGND sg13g2_dfrbpq_1
X_5612_ _5612_/Y _9418_/Q _5621_/B VPWR VGND sg13g2_nand2_1
X_5543_ _5543_/Y _5585_/A _5585_/B _8637_/Q _5585_/D VPWR VGND sg13g2_nand4_1
X_8331_ _8331_/Y _9166_/Q _8343_/B VPWR VGND sg13g2_nand2_1
X_8262_ _9131_/D _8563_/D _7928_/Y _8261_/Y VPWR VGND sg13g2_o21ai_1
X_5474_ _8695_/D _5474_/A _6737_/C VPWR VGND sg13g2_nor2b_1
X_7213_ _8887_/D _7212_/Y _8887_/Q _7213_/S VPWR VGND sg13g2_mux2_1
X_4425_ _4425_/Y _6262_/A _4425_/B _4425_/C _6262_/C VPWR VGND sg13g2_nand4_1
X_8193_ _8193_/Y _9097_/Q _8197_/B VPWR VGND sg13g2_nand2_1
X_4356_ _4618_/B _9682_/Q _5491_/B VPWR VGND sg13g2_nand2_1
X_7144_ _7144_/Y _7156_/A _8867_/Q VPWR VGND sg13g2_nand2_1
XFILLER_59_638 VPWR VGND sg13g2_decap_4
X_7075_ _7075_/Y _5356_/C _6967_/Y _7074_/Y VPWR VGND sg13g2_o21ai_1
XFILLER_104_24 VPWR VGND sg13g2_fill_1
XFILLER_101_779 VPWR VGND sg13g2_decap_8
XFILLER_58_159 VPWR VGND sg13g2_fill_1
X_6026_ _6049_/B _6338_/B _6064_/B _6064_/A VPWR VGND sg13g2_nand3b_1
XFILLER_100_289 VPWR VGND sg13g2_decap_8
XFILLER_67_693 VPWR VGND sg13g2_decap_4
XFILLER_27_535 VPWR VGND sg13g2_fill_1
XFILLER_39_384 VPWR VGND sg13g2_decap_8
XFILLER_27_568 VPWR VGND sg13g2_fill_2
XFILLER_81_162 VPWR VGND sg13g2_decap_8
X_7977_ _7977_/Y _7985_/A _8999_/Q _8375_/C VPWR VGND sg13g2_nand3_1
XFILLER_42_516 VPWR VGND sg13g2_fill_1
XFILLER_120_56 VPWR VGND sg13g2_decap_8
XFILLER_54_398 VPWR VGND sg13g2_decap_4
X_6928_ _6928_/Y _9698_/Q _9706_/Q _6937_/B VPWR VGND sg13g2_o21ai_1
XFILLER_23_741 VPWR VGND sg13g2_decap_8
XFILLER_120_78 VPWR VGND sg13g2_fill_2
XFILLER_120_67 VPWR VGND sg13g2_fill_1
X_9647_ _9647_/Q _9649_/CLK _9647_/D fanout973/X VPWR VGND sg13g2_dfrbpq_1
X_6859_ _6859_/X _8903_/Q _8935_/Q _6905_/S VPWR VGND sg13g2_mux2_1
XFILLER_23_774 VPWR VGND sg13g2_decap_8
XFILLER_22_284 VPWR VGND sg13g2_decap_8
X_9578_ _9578_/Q _9588_/CLK _9578_/D _9578_/RESET_B VPWR VGND sg13g2_dfrbpq_1
X_8529_ _8529_/Y _8528_/X _8526_/Y _8534_/A VPWR VGND sg13g2_o21ai_1
XFILLER_89_14 VPWR VGND sg13g2_decap_8
XFILLER_13_98 VPWR VGND sg13g2_fill_1
XFILLER_2_623 VPWR VGND sg13g2_fill_2
XFILLER_77_402 VPWR VGND sg13g2_decap_4
XFILLER_77_446 VPWR VGND sg13g2_fill_1
XFILLER_77_435 VPWR VGND sg13g2_fill_2
XFILLER_49_148 VPWR VGND sg13g2_decap_4
Xfanout960 fanout960/X fanout985/X VPWR VGND sg13g2_buf_1
Xfanout971 fanout971/X fanout972/X VPWR VGND sg13g2_buf_1
Xfanout982 fanout982/X fanout984/X VPWR VGND sg13g2_buf_1
XFILLER_65_619 VPWR VGND sg13g2_decap_8
XFILLER_64_107 VPWR VGND sg13g2_decap_8
XFILLER_38_73 VPWR VGND sg13g2_fill_2
XFILLER_18_557 VPWR VGND sg13g2_decap_8
XFILLER_72_162 VPWR VGND sg13g2_decap_4
XFILLER_33_527 VPWR VGND sg13g2_decap_8
XFILLER_14_741 VPWR VGND sg13g2_fill_2
XFILLER_26_590 VPWR VGND sg13g2_decap_4
XFILLER_13_240 VPWR VGND sg13g2_fill_1
XFILLER_13_262 VPWR VGND sg13g2_fill_2
XFILLER_41_571 VPWR VGND sg13g2_decap_4
XFILLER_70_71 VPWR VGND sg13g2_decap_8
Xclkload25 clkload25/Y _9409_/CLK VPWR VGND sg13g2_inv_8
Xclkload14 clkload14/Y _9407_/CLK VPWR VGND sg13g2_inv_1
Xclkload36 clkload36/X _9582_/CLK VPWR VGND sg13g2_buf_8
X_5190_ _5190_/Y _5192_/C _5190_/B VPWR VGND sg13g2_nand2_1
XFILLER_110_521 VPWR VGND sg13g2_fill_2
Xclkbuf_0_clk_i clkbuf_0_clk_i/X clk_i VPWR VGND sg13g2_buf_8
XFILLER_49_671 VPWR VGND sg13g2_fill_1
X_7900_ _8964_/D _5349_/C _7899_/A _7899_/Y VPWR VGND sg13g2_o21ai_1
X_8880_ _8880_/Q _9253_/CLK _8880_/D place2479/X VPWR VGND sg13g2_dfrbpq_1
XFILLER_64_696 VPWR VGND sg13g2_decap_4
X_7831_ _7845_/C _7831_/A _8894_/Q _7831_/C VPWR VGND sg13g2_nand3_1
XFILLER_36_376 VPWR VGND sg13g2_decap_8
X_7762_ _7763_/D _9078_/Q _7627_/B _7761_/X VPWR VGND sg13g2_o21ai_1
X_4974_ _4974_/Y _4974_/A _4974_/B _4974_/C VPWR VGND sg13g2_nand3_1
X_6713_ _9481_/D _9522_/Q _9481_/Q _6714_/S VPWR VGND sg13g2_mux2_1
X_7693_ _7696_/B _7687_/Y _7692_/Y _8095_/D VPWR VGND sg13g2_o21ai_1
X_9501_ _9501_/Q _9501_/CLK _9501_/D _9501_/RESET_B VPWR VGND sg13g2_dfrbpq_1
X_6644_ _9444_/D _6653_/A1 _6643_/Y _6641_/Y VPWR VGND sg13g2_o21ai_1
X_9432_ _9432_/Q _9645_/CLK _9432_/D fanout979/X VPWR VGND sg13g2_dfrbpq_1
XFILLER_50_19 VPWR VGND sg13g2_decap_8
Xclkload8 clkload8/Y clkload8/A VPWR VGND sg13g2_inv_2
XFILLER_118_632 VPWR VGND sg13g2_fill_1
X_6575_ _6575_/Y _6588_/C _8626_/Q _9558_/Q _6566_/Y VPWR VGND sg13g2_a22oi_1
X_9363_ _9363_/Q _9406_/CLK _9363_/D place2390/X VPWR VGND sg13g2_dfrbpq_1
X_9294_ _9294_/Q _9305_/CLK _9294_/D place2395/X VPWR VGND sg13g2_dfrbpq_1
X_5526_ _5526_/Y _9428_/Q _5600_/B _5601_/B1 _8630_/Q VPWR VGND sg13g2_a22oi_1
X_8314_ _9157_/D _8314_/A1 _8053_/Y _8313_/Y VPWR VGND sg13g2_o21ai_1
X_5457_ _5458_/A _5469_/A1 _8687_/Q _8688_/Q _5467_/B2 VPWR VGND sg13g2_a22oi_1
X_8245_ _8245_/Y _8245_/A _8251_/B VPWR VGND sg13g2_nand2_1
XFILLER_121_808 VPWR VGND sg13g2_fill_1
XFILLER_105_348 VPWR VGND sg13g2_decap_8
Xoutput2673 master_addr_o[20] _9878_/X VPWR VGND sg13g2_buf_1
Xoutput2662 master_addr_o[10] _9868_/X VPWR VGND sg13g2_buf_1
XFILLER_59_17 VPWR VGND sg13g2_decap_8
X_4408_ _4409_/A _4387_/Y _8665_/Q _8666_/Q _4388_/X VPWR VGND sg13g2_a22oi_1
X_5388_ _5388_/Y _9493_/Q _5388_/B VPWR VGND sg13g2_nor2_1
Xoutput2684 master_addr_o[30] _9888_/X VPWR VGND sg13g2_buf_1
XFILLER_87_722 VPWR VGND sg13g2_fill_2
Xoutput2695 master_be_o[2] _5053_/Y VPWR VGND sg13g2_buf_1
X_8176_ _9088_/D _8190_/A1 _8034_/Y _8175_/Y VPWR VGND sg13g2_o21ai_1
XFILLER_120_329 VPWR VGND sg13g2_decap_4
XFILLER_115_45 VPWR VGND sg13g2_decap_8
X_4339_ _8708_/D _8713_/Q VPWR VGND sg13g2_inv_1
XFILLER_101_510 VPWR VGND sg13g2_decap_8
X_7127_ _7127_/Y _5373_/C _7127_/A2 _7126_/Y VPWR VGND sg13g2_o21ai_1
XFILLER_101_576 VPWR VGND sg13g2_decap_8
XFILLER_75_27 VPWR VGND sg13g2_fill_2
XFILLER_74_405 VPWR VGND sg13g2_decap_4
XFILLER_59_457 VPWR VGND sg13g2_fill_2
X_7058_ _7058_/Y _8039_/D _6966_/Y _7036_/X _4435_/C VPWR VGND sg13g2_a22oi_1
XFILLER_86_276 VPWR VGND sg13g2_decap_8
X_6009_ _9340_/D _9340_/Q _6041_/A _6539_/S VPWR VGND sg13g2_mux2_1
XFILLER_39_170 VPWR VGND sg13g2_decap_8
XFILLER_55_652 VPWR VGND sg13g2_decap_4
XFILLER_82_460 VPWR VGND sg13g2_fill_2
XFILLER_55_674 VPWR VGND sg13g2_decap_8
XFILLER_54_195 VPWR VGND sg13g2_fill_1
XFILLER_15_549 VPWR VGND sg13g2_decap_4
XFILLER_42_324 VPWR VGND sg13g2_decap_8
XFILLER_42_346 VPWR VGND sg13g2_decap_8
XFILLER_24_31 VPWR VGND sg13g2_fill_1
XFILLER_42_357 VPWR VGND sg13g2_fill_2
XFILLER_23_571 VPWR VGND sg13g2_fill_1
XFILLER_11_755 VPWR VGND sg13g2_decap_8
XFILLER_10_254 VPWR VGND sg13g2_decap_8
XFILLER_109_654 VPWR VGND sg13g2_decap_8
XFILLER_108_120 VPWR VGND sg13g2_decap_8
XFILLER_6_269 VPWR VGND sg13g2_fill_2
XFILLER_109_698 VPWR VGND sg13g2_decap_8
XFILLER_123_112 VPWR VGND sg13g2_decap_8
XFILLER_6_0 VPWR VGND sg13g2_decap_8
XFILLER_2_431 VPWR VGND sg13g2_decap_4
XFILLER_111_318 VPWR VGND sg13g2_decap_8
X_9603__2787 _9603_/RESET_B VPWR VGND sg13g2_tiehi
XFILLER_104_381 VPWR VGND sg13g2_decap_8
XFILLER_49_61 VPWR VGND sg13g2_fill_1
XFILLER_93_736 VPWR VGND sg13g2_decap_8
XFILLER_92_213 VPWR VGND sg13g2_decap_8
XFILLER_78_799 VPWR VGND sg13g2_fill_2
XFILLER_65_416 VPWR VGND sg13g2_fill_2
XFILLER_1_35 VPWR VGND sg13g2_decap_8
XFILLER_80_408 VPWR VGND sg13g2_decap_8
Xclkbuf_2_0__f_jtag_tck_i_regs clkbuf_leaf_6_jtag_tck_i_regs/A clkbuf_0_jtag_tck_i_regs/X
+ VPWR VGND sg13g2_buf_8
XFILLER_61_622 VPWR VGND sg13g2_decap_4
XFILLER_18_387 VPWR VGND sg13g2_fill_2
XFILLER_18_398 VPWR VGND sg13g2_fill_2
XFILLER_81_81 VPWR VGND sg13g2_fill_1
XFILLER_14_593 VPWR VGND sg13g2_decap_4
X_4690_ _4693_/B _9551_/Q _8740_/Q _9552_/Q VPWR VGND sg13g2_nor3_1
X_6360_ _6360_/Y _6357_/Y _6359_/Y _6392_/S VPWR VGND sg13g2_a21oi_1
X_5311_ _5311_/Y _9882_/A _9883_/A _9884_/A _5329_/B VPWR VGND sg13g2_nand4_1
Xplace1915 _5366_/A _8563_/B VPWR VGND sg13g2_buf_1
Xplace1926 _6463_/A2 _6312_/A VPWR VGND sg13g2_buf_1
Xplace1904 _6512_/A1 _6055_/A VPWR VGND sg13g2_buf_1
XFILLER_115_646 VPWR VGND sg13g2_decap_8
Xplace1937 _7809_/B1 _7737_/B1 VPWR VGND sg13g2_buf_1
Xplace1959 _6515_/B1 _6430_/B2 VPWR VGND sg13g2_buf_1
X_8030_ _9024_/D _8100_/A1 _8029_/Y _8028_/Y VPWR VGND sg13g2_o21ai_1
Xplace1948 _6462_/A2 _6958_/C VPWR VGND sg13g2_buf_1
X_6291_ _6291_/Y _9236_/Q _6516_/C VPWR VGND sg13g2_nand2_1
XFILLER_114_178 VPWR VGND sg13g2_decap_4
X_5242_ _5242_/Y _5242_/A _5242_/B _5242_/C VPWR VGND sg13g2_nor3_1
X_5173_ _5173_/Y _5187_/C _5159_/Y _5169_/A _5169_/B VPWR VGND sg13g2_a22oi_1
XFILLER_83_202 VPWR VGND sg13g2_fill_1
XFILLER_84_769 VPWR VGND sg13g2_decap_8
X_8932_ _8932_/Q _9198_/CLK _8932_/D place2451/X VPWR VGND sg13g2_dfrbpq_1
XFILLER_37_652 VPWR VGND sg13g2_decap_8
XFILLER_64_471 VPWR VGND sg13g2_fill_1
X_8863_ _8863_/Q _9407_/CLK _8863_/D place2488/X VPWR VGND sg13g2_dfrbpq_1
XFILLER_24_302 VPWR VGND sg13g2_fill_1
XFILLER_37_685 VPWR VGND sg13g2_fill_1
XFILLER_52_622 VPWR VGND sg13g2_decap_8
X_7814_ _7817_/A _7819_/C _9143_/Q _7820_/C VPWR VGND sg13g2_nor3_1
X_8794_ _8794_/Q _9253_/CLK _8794_/D place2456/X VPWR VGND sg13g2_dfrbpq_1
XFILLER_101_69 VPWR VGND sg13g2_fill_2
X_7745_ _7749_/D _9170_/Q _7782_/B VPWR VGND sg13g2_nor2_1
XFILLER_51_187 VPWR VGND sg13g2_fill_1
X_4957_ _5020_/B _4983_/A _4983_/B _4957_/C _4957_/D VPWR VGND sg13g2_nand4_1
X_7676_ _7676_/Y _7676_/A _7676_/B _7676_/C _7676_/D VPWR VGND sg13g2_nand4_1
Xinput2549 _7613_/A1 hartinfo_i[18] VPWR VGND sg13g2_buf_1
X_4888_ _4888_/Y _4820_/B _4928_/C _4995_/S VPWR VGND sg13g2_a21oi_1
X_6627_ _9439_/D _6653_/A1 _6626_/Y _6625_/Y VPWR VGND sg13g2_o21ai_1
X_9415_ _9415_/Q _9511_/CLK _9415_/D fanout957/X VPWR VGND sg13g2_dfrbpq_1
X_9346_ _9346_/Q _9414_/CLK _9346_/D place2503/X VPWR VGND sg13g2_dfrbpq_1
X_6558_ _6558_/X _6558_/A _9421_/Q _6737_/A _6558_/D VPWR VGND sg13g2_and4_1
XFILLER_106_668 VPWR VGND sg13g2_decap_8
X_9277_ _9277_/Q _9305_/CLK _9277_/D place2405/X VPWR VGND sg13g2_dfrbpq_1
X_5509_ _8624_/D _5508_/Y _5507_/Y _5602_/B1 VPWR VGND sg13g2_a21oi_1
X_6489_ _6489_/Y _8891_/Q _6496_/A2 _6488_/Y _6410_/Y _6487_/Y VPWR VGND sg13g2_a221oi_1
X_8228_ _9114_/D _8252_/A1 _8022_/Y _8227_/Y VPWR VGND sg13g2_o21ai_1
XFILLER_120_137 VPWR VGND sg13g2_decap_8
XFILLER_114_690 VPWR VGND sg13g2_fill_2
X_8159_ _8159_/Y _9080_/Q _8159_/B VPWR VGND sg13g2_nand2_1
XFILLER_90_706 VPWR VGND sg13g2_fill_2
XFILLER_70_463 VPWR VGND sg13g2_decap_8
XFILLER_70_485 VPWR VGND sg13g2_decap_4
XFILLER_11_574 VPWR VGND sg13g2_fill_1
XFILLER_7_501 VPWR VGND sg13g2_fill_2
XFILLER_7_545 VPWR VGND sg13g2_decap_4
XFILLER_109_484 VPWR VGND sg13g2_decap_4
XFILLER_7_578 VPWR VGND sg13g2_decap_4
XFILLER_112_605 VPWR VGND sg13g2_decap_8
XFILLER_97_338 VPWR VGND sg13g2_decap_8
XFILLER_111_148 VPWR VGND sg13g2_fill_1
XFILLER_111_137 VPWR VGND sg13g2_decap_8
XFILLER_38_416 VPWR VGND sg13g2_decap_8
Xclkbuf_leaf_16_clk_i _9409_/CLK clkload3/A VPWR VGND sg13g2_buf_16
XFILLER_34_600 VPWR VGND sg13g2_decap_8
X_5860_ _5860_/Y _5939_/A _5857_/X _5925_/C VPWR VGND sg13g2_o21ai_1
XFILLER_33_110 VPWR VGND sg13g2_decap_8
X_4811_ _4811_/Y _4898_/C _4924_/B _4880_/D VPWR VGND sg13g2_o21ai_1
X_5791_ _9288_/D _5791_/A VPWR VGND sg13g2_inv_1
X_4742_ _4743_/B _4590_/A _4590_/B _4572_/B VPWR VGND sg13g2_a21oi_1
X_7530_ _7530_/Y _7822_/A _7530_/B _7530_/C _7530_/D VPWR VGND sg13g2_nor4_1
XFILLER_119_226 VPWR VGND sg13g2_fill_2
X_4673_ _4674_/C _8719_/Q _4673_/B VPWR VGND sg13g2_nor2_1
X_7461_ _7461_/X _7775_/A _9285_/Q _7461_/C _7519_/D VPWR VGND sg13g2_and4_1
Xplace2413 place2413/X place2421/X VPWR VGND sg13g2_buf_1
Xplace2402 place2402/X place2403/X VPWR VGND sg13g2_buf_1
X_9200_ _9200_/Q clkload7/A _9200_/D place2458/X VPWR VGND sg13g2_dfrbpq_1
X_6412_ _9389_/D _6253_/S _6411_/Y _6409_/Y VPWR VGND sg13g2_o21ai_1
Xplace2446 place2446/X place2448/X VPWR VGND sg13g2_buf_1
Xplace2424 place2424/X place2425/X VPWR VGND sg13g2_buf_1
X_7392_ _7395_/B _8871_/Q _7533_/B1 _6994_/Y _7392_/B2 VPWR VGND sg13g2_a22oi_1
Xplace2435 place2435/X place2436/X VPWR VGND sg13g2_buf_1
XFILLER_115_410 VPWR VGND sg13g2_fill_1
X_9131_ _9131_/Q _9603_/CLK _9131_/D place2411/X VPWR VGND sg13g2_dfrbpq_1
Xplace2457 place2457/X place2459/X VPWR VGND sg13g2_buf_1
X_6343_ _6343_/X _8991_/Q _9053_/Q _9115_/Q _9177_/Q _6061_/A _6349_/S1 VPWR VGND
+ sg13g2_mux4_1
Xplace2468 place2468/X place2473/X VPWR VGND sg13g2_buf_1
Xplace2479 place2479/X place2487/X VPWR VGND sg13g2_buf_1
Xhold3104 _8091_/A _9047_/Q VPWR VGND sg13g2_dlygate4sd3_1
Xplace1778 _6671_/B _6587_/B VPWR VGND sg13g2_buf_1
Xhold3115 _8235_/A _9118_/Q VPWR VGND sg13g2_dlygate4sd3_1
X_9062_ _9062_/Q _9188_/CLK _9062_/D place2483/X VPWR VGND sg13g2_dfrbpq_1
X_6274_ _6274_/Y _6325_/A1 _6273_/Y _6229_/B VPWR VGND sg13g2_o21ai_1
Xplace1789 _5935_/A2 _5837_/Y VPWR VGND sg13g2_buf_1
Xhold3126 _8147_/A _9074_/Q VPWR VGND sg13g2_dlygate4sd3_1
X_5225_ _8765_/D _5274_/A1 _5357_/C _5224_/Y _5269_/A1 VPWR VGND sg13g2_a22oi_1
Xhold3137 _8227_/A _9114_/Q VPWR VGND sg13g2_dlygate4sd3_1
Xhold3148 _5429_/A1 _8668_/Q VPWR VGND sg13g2_dlygate4sd3_1
X_8013_ _8013_/Y _8017_/A _9017_/Q _8411_/C VPWR VGND sg13g2_nand3_1
Xhold3159 _5665_/B2 _8609_/Q VPWR VGND sg13g2_dlygate4sd3_1
XFILLER_111_671 VPWR VGND sg13g2_decap_8
X_5156_ _5156_/Y _5175_/B _5175_/C _5178_/A _5158_/D VPWR VGND sg13g2_nand4_1
XFILLER_110_181 VPWR VGND sg13g2_decap_8
XFILLER_96_393 VPWR VGND sg13g2_decap_4
X_5087_ _5089_/B _5086_/B _5763_/B1 _5736_/A VPWR VGND sg13g2_o21ai_1
X_8915_ _8915_/Q _9615_/CLK _8915_/D place2418/X VPWR VGND sg13g2_dfrbpq_1
XFILLER_44_408 VPWR VGND sg13g2_decap_4
XFILLER_71_216 VPWR VGND sg13g2_decap_8
XFILLER_80_761 VPWR VGND sg13g2_decap_8
X_8846_ _8846_/Q _9251_/CLK _8846_/D place2477/X VPWR VGND sg13g2_dfrbpq_1
X_5989_ _5989_/Y _5989_/A _6004_/B _6004_/C VPWR VGND sg13g2_nand3_1
X_8777_ _9883_/A _9260_/CLK _8777_/D place2394/X VPWR VGND sg13g2_dfrbpq_1
XFILLER_52_496 VPWR VGND sg13g2_decap_4
X_7728_ _7733_/A _7722_/Y _7727_/Y _4560_/B VPWR VGND sg13g2_o21ai_1
XFILLER_12_349 VPWR VGND sg13g2_decap_8
XFILLER_8_309 VPWR VGND sg13g2_fill_2
X_7659_ _7661_/A _9879_/A _7825_/A2 _7825_/B1 _7659_/B2 VPWR VGND sg13g2_a22oi_1
XFILLER_21_54 VPWR VGND sg13g2_decap_8
X_9329_ _9329_/Q _9410_/CLK _9329_/D place2396/X VPWR VGND sg13g2_dfrbpq_1
XFILLER_97_36 VPWR VGND sg13g2_fill_2
X_9512__2868 _9512_/RESET_B VPWR VGND sg13g2_tiehi
XFILLER_102_671 VPWR VGND sg13g2_decap_4
XFILLER_75_522 VPWR VGND sg13g2_decap_8
XFILLER_101_192 VPWR VGND sg13g2_fill_2
Xhold2970 _6232_/B1 _9364_/Q VPWR VGND sg13g2_dlygate4sd3_1
Xhold2992 _6289_/B1 _9369_/Q VPWR VGND sg13g2_dlygate4sd3_1
Xhold2981 _6217_/B1 _9362_/Q VPWR VGND sg13g2_dlygate4sd3_1
XFILLER_47_246 VPWR VGND sg13g2_fill_1
XFILLER_75_566 VPWR VGND sg13g2_decap_8
XFILLER_46_40 VPWR VGND sg13g2_fill_1
XFILLER_62_216 VPWR VGND sg13g2_fill_1
XFILLER_46_62 VPWR VGND sg13g2_decap_8
XFILLER_16_688 VPWR VGND sg13g2_decap_8
XFILLER_31_636 VPWR VGND sg13g2_decap_8
XFILLER_43_496 VPWR VGND sg13g2_fill_1
XFILLER_31_647 VPWR VGND sg13g2_fill_2
XFILLER_7_56 VPWR VGND sg13g2_decap_8
XFILLER_116_229 VPWR VGND sg13g2_decap_8
XFILLER_7_386 VPWR VGND sg13g2_decap_4
XFILLER_97_157 VPWR VGND sg13g2_decap_4
X_5010_ _5010_/Y _5009_/Y _5010_/B VPWR VGND sg13g2_nand2b_1
XFILLER_39_725 VPWR VGND sg13g2_fill_1
XFILLER_39_736 VPWR VGND sg13g2_decap_4
XFILLER_54_717 VPWR VGND sg13g2_decap_8
X_8700_ _8700_/Q _9645_/CLK _8700_/D fanout977/X VPWR VGND sg13g2_dfrbpq_1
XFILLER_47_780 VPWR VGND sg13g2_fill_2
XFILLER_19_493 VPWR VGND sg13g2_fill_2
X_6961_ _6961_/Y _7010_/A _6960_/Y _6959_/Y VPWR VGND sg13g2_a21oi_1
X_6892_ _9612_/D _6891_/X _9612_/Q _6910_/S VPWR VGND sg13g2_mux2_1
X_5912_ _5912_/Y _9316_/Q _6006_/S VPWR VGND sg13g2_nand2_1
X_9680_ _9680_/Q _9689_/CLK _9680_/D fanout963/X VPWR VGND sg13g2_dfrbpq_1
XFILLER_46_290 VPWR VGND sg13g2_decap_8
X_5843_ _5844_/A _5905_/A _5843_/A2 _5842_/X VPWR VGND sg13g2_a21oi_1
X_8631_ _8631_/Q _9587_/CLK _8631_/D fanout968/X VPWR VGND sg13g2_dfrbpq_1
XFILLER_61_271 VPWR VGND sg13g2_fill_2
XFILLER_34_485 VPWR VGND sg13g2_decap_8
X_8562_ _8562_/Y _8577_/A _8577_/B _9274_/Q VPWR VGND sg13g2_nand3_1
XFILLER_21_124 VPWR VGND sg13g2_fill_2
XFILLER_21_135 VPWR VGND sg13g2_fill_1
X_5774_ _5774_/X _9315_/Q _9331_/Q _9307_/Q _9323_/Q _5050_/Y _5843_/A2 VPWR VGND
+ sg13g2_mux4_1
X_7513_ _7513_/Y _9264_/Q _7520_/B _7809_/B1 _7513_/B2 VPWR VGND sg13g2_a22oi_1
X_9562__2828 _9562_/RESET_B VPWR VGND sg13g2_tiehi
X_4725_ _4726_/B _9684_/Q _4729_/A _9686_/Q VPWR VGND sg13g2_a21oi_1
XFILLER_30_680 VPWR VGND sg13g2_fill_2
X_8493_ _9251_/D _8488_/A _5366_/C _8492_/Y VPWR VGND sg13g2_o21ai_1
Xplace2210 _5585_/B _5597_/B VPWR VGND sg13g2_buf_1
X_4656_ _9649_/D _6953_/S _4660_/A _4655_/Y VPWR VGND sg13g2_o21ai_1
Xplace2221 _7245_/B _9468_/Q VPWR VGND sg13g2_buf_1
X_7444_ _7448_/D _9155_/Q _7491_/B _7489_/A VPWR VGND sg13g2_o21ai_1
X_7375_ _7376_/A _9280_/Q _7557_/A2 _7557_/B1 _9312_/Q VPWR VGND sg13g2_a22oi_1
Xplace2232 _7775_/A _5827_/A VPWR VGND sg13g2_buf_1
Xplace2243 _7690_/A _7747_/A VPWR VGND sg13g2_buf_1
Xplace2254 _7492_/A _7469_/A VPWR VGND sg13g2_buf_1
X_4587_ _4589_/C _5628_/B _9695_/Q _4587_/C VPWR VGND sg13g2_nor3_1
Xplace2265 _7237_/A1 _7831_/A VPWR VGND sg13g2_buf_1
Xplace2287 _6010_/A0 _9341_/Q VPWR VGND sg13g2_buf_1
X_9114_ _9114_/Q clkload5/A _9114_/D place2499/X VPWR VGND sg13g2_dfrbpq_1
Xplace2298 _4827_/B _4793_/B VPWR VGND sg13g2_buf_1
Xplace2276 _7834_/B _9464_/Q VPWR VGND sg13g2_buf_1
X_6326_ _6326_/X _8989_/Q _9051_/Q _9113_/Q _9175_/Q _6421_/S0 _6421_/S1 VPWR VGND
+ sg13g2_mux4_1
XFILLER_107_68 VPWR VGND sg13g2_decap_8
XFILLER_88_135 VPWR VGND sg13g2_fill_1
X_6257_ _6265_/B _8856_/Q _7237_/B2 _6256_/X _6515_/B1 VPWR VGND sg13g2_a22oi_1
X_9045_ _9045_/Q clkload6/A _9045_/D place2434/X VPWR VGND sg13g2_dfrbpq_1
X_5208_ _8762_/D _5274_/A1 _5354_/C _5207_/Y _5269_/A1 VPWR VGND sg13g2_a22oi_1
X_6188_ _6189_/D _6188_/A _6190_/D _9250_/Q VPWR VGND sg13g2_nand3_1
X_5139_ _5139_/Y _5191_/A _5139_/B VPWR VGND sg13g2_xnor2_1
XFILLER_57_533 VPWR VGND sg13g2_decap_8
XFILLER_123_56 VPWR VGND sg13g2_decap_8
XFILLER_72_514 VPWR VGND sg13g2_fill_2
XFILLER_57_555 VPWR VGND sg13g2_fill_2
XFILLER_29_268 VPWR VGND sg13g2_decap_8
XFILLER_16_10 VPWR VGND sg13g2_decap_4
XFILLER_38_791 VPWR VGND sg13g2_fill_1
X_9878_ _9878_/X _9878_/A VPWR VGND sg13g2_buf_1
XFILLER_60_709 VPWR VGND sg13g2_decap_8
XFILLER_16_21 VPWR VGND sg13g2_fill_2
XFILLER_16_32 VPWR VGND sg13g2_decap_4
X_8829_ _8829_/Q _9504_/CLK _8829_/D place2428/X VPWR VGND sg13g2_dfrbpq_1
XFILLER_13_647 VPWR VGND sg13g2_decap_8
XFILLER_13_658 VPWR VGND sg13g2_fill_2
XFILLER_40_455 VPWR VGND sg13g2_fill_1
XFILLER_122_711 VPWR VGND sg13g2_decap_4
XFILLER_121_243 VPWR VGND sg13g2_decap_8
XFILLER_95_606 VPWR VGND sg13g2_fill_2
XFILLER_0_540 VPWR VGND sg13g2_decap_8
XFILLER_121_254 VPWR VGND sg13g2_fill_1
XFILLER_0_573 VPWR VGND sg13g2_decap_8
XFILLER_36_717 VPWR VGND sg13g2_fill_2
XFILLER_90_366 VPWR VGND sg13g2_decap_8
XFILLER_16_430 VPWR VGND sg13g2_fill_1
XFILLER_90_377 VPWR VGND sg13g2_fill_2
XFILLER_73_71 VPWR VGND sg13g2_fill_2
XFILLER_50_208 VPWR VGND sg13g2_decap_8
XFILLER_16_463 VPWR VGND sg13g2_decap_8
XFILLER_31_422 VPWR VGND sg13g2_decap_8
XFILLER_31_444 VPWR VGND sg13g2_decap_8
XFILLER_78_4 VPWR VGND sg13g2_fill_2
X_4510_ _7024_/C _7002_/B _7002_/C _7002_/D _8515_/B VPWR VGND sg13g2_nand4_1
X_5490_ _5491_/D _9207_/Q _9688_/Q VPWR VGND sg13g2_nor2_1
XFILLER_7_172 VPWR VGND sg13g2_decap_8
X_4441_ _4443_/A _7191_/A _7187_/B _7198_/A _7194_/B VPWR VGND sg13g2_nor4_1
X_7160_ _7185_/S _7168_/D _6962_/Y _6974_/Y VPWR VGND sg13g2_o21ai_1
X_4372_ _4373_/B _8712_/Q _9655_/Q VPWR VGND sg13g2_nand2b_1
XFILLER_113_733 VPWR VGND sg13g2_decap_8
XFILLER_113_711 VPWR VGND sg13g2_decap_8
X_6111_ _9348_/D _6107_/Y _6109_/Y _6110_/Y VPWR VGND sg13g2_a21oi_1
XFILLER_113_744 VPWR VGND sg13g2_fill_1
X_7091_ _7091_/Y _8483_/A2 _7127_/A2 _7090_/Y VPWR VGND sg13g2_o21ai_1
XFILLER_100_405 VPWR VGND sg13g2_decap_8
X_6042_ _6042_/Y _8589_/A _6338_/B _6042_/C VPWR VGND sg13g2_nor3_1
XFILLER_85_127 VPWR VGND sg13g2_decap_8
XFILLER_66_363 VPWR VGND sg13g2_fill_1
XFILLER_66_341 VPWR VGND sg13g2_fill_1
X_9616__2774 _9616_/RESET_B VPWR VGND sg13g2_tiehi
X_7993_ _7993_/Y _8011_/A _9007_/Q _8403_/C VPWR VGND sg13g2_nand3_1
XFILLER_66_385 VPWR VGND sg13g2_fill_1
XFILLER_54_536 VPWR VGND sg13g2_fill_2
XFILLER_27_728 VPWR VGND sg13g2_fill_1
X_6944_ _6945_/C _8622_/Q _8623_/Q VPWR VGND sg13g2_nand2b_1
X_9663_ _9663_/Q _9672_/CLK _9663_/D place2451/X VPWR VGND sg13g2_dfrbpq_1
X_6875_ _6875_/X _8911_/Q _8943_/Q _6909_/S VPWR VGND sg13g2_mux2_1
XFILLER_34_282 VPWR VGND sg13g2_fill_2
X_8614_ _8614_/Q _9689_/CLK _8614_/D fanout961/X VPWR VGND sg13g2_dfrbpq_1
X_5826_ _6523_/C _5826_/A _7244_/D VPWR VGND sg13g2_nor2_1
X_9594_ _9594_/Q _9672_/CLK _9594_/D _9594_/RESET_B VPWR VGND sg13g2_dfrbpq_1
XFILLER_10_606 VPWR VGND sg13g2_fill_1
X_5757_ _5757_/Y _9326_/Q _5769_/B VPWR VGND sg13g2_nand2b_1
X_8545_ _9265_/D _8563_/A _8543_/X _8544_/Y VPWR VGND sg13g2_o21ai_1
XFILLER_108_505 VPWR VGND sg13g2_fill_1
X_4708_ _9671_/D _4708_/A _4708_/B VPWR VGND sg13g2_nor2_1
X_8476_ _8476_/Y _8476_/A _9243_/Q _8490_/C VPWR VGND sg13g2_nand3_1
X_5688_ _8597_/D _5688_/A VPWR VGND sg13g2_inv_1
X_7427_ _7429_/C _7486_/A _8999_/Q _7490_/C VPWR VGND sg13g2_nor3_1
Xplace2051 _5601_/B1 _5523_/B1 VPWR VGND sg13g2_buf_1
X_4639_ _4640_/C _9648_/Q _6743_/C VPWR VGND sg13g2_nor2_1
Xplace2062 _6666_/A2 _5478_/Y VPWR VGND sg13g2_buf_1
Xplace2073 _5366_/D _5373_/D VPWR VGND sg13g2_buf_1
XFILLER_2_805 VPWR VGND sg13g2_decap_4
Xplace2040 _8198_/A1 _5836_/D VPWR VGND sg13g2_buf_1
Xplace2084 _5889_/S _5952_/A VPWR VGND sg13g2_buf_1
XFILLER_104_722 VPWR VGND sg13g2_decap_8
Xplace2095 _5906_/A2 _5083_/A VPWR VGND sg13g2_buf_1
X_7358_ _7358_/Y _7358_/A _7358_/B _7358_/C VPWR VGND sg13g2_nand3_1
XFILLER_103_243 VPWR VGND sg13g2_decap_4
X_7289_ _8897_/D _8897_/Q _7288_/Y _7848_/S VPWR VGND sg13g2_mux2_1
X_6309_ _6309_/Y _6309_/A _6309_/B _6958_/C VPWR VGND sg13g2_nor3_1
XFILLER_103_276 VPWR VGND sg13g2_fill_1
X_9028_ _9028_/Q _9183_/CLK _9028_/D place2472/X VPWR VGND sg13g2_dfrbpq_1
XFILLER_85_661 VPWR VGND sg13g2_fill_2
XFILLER_85_650 VPWR VGND sg13g2_fill_2
XFILLER_60_506 VPWR VGND sg13g2_decap_4
XFILLER_25_260 VPWR VGND sg13g2_decap_8
XFILLER_53_591 VPWR VGND sg13g2_decap_8
XFILLER_13_433 VPWR VGND sg13g2_fill_1
XFILLER_25_282 VPWR VGND sg13g2_fill_1
XFILLER_41_742 VPWR VGND sg13g2_decap_8
XFILLER_4_131 VPWR VGND sg13g2_fill_2
XFILLER_4_120 VPWR VGND sg13g2_decap_8
XFILLER_107_571 VPWR VGND sg13g2_decap_8
XFILLER_4_35 VPWR VGND sg13g2_decap_8
XFILLER_95_447 VPWR VGND sg13g2_decap_8
XFILLER_63_311 VPWR VGND sg13g2_decap_8
XFILLER_91_664 VPWR VGND sg13g2_decap_8
XFILLER_84_81 VPWR VGND sg13g2_decap_8
XFILLER_91_697 VPWR VGND sg13g2_decap_8
XFILLER_91_675 VPWR VGND sg13g2_fill_1
XFILLER_63_377 VPWR VGND sg13g2_fill_1
X_4990_ _4990_/Y _4798_/Y _4989_/Y _4987_/Y VPWR VGND sg13g2_a21oi_1
XFILLER_51_539 VPWR VGND sg13g2_decap_8
XFILLER_17_794 VPWR VGND sg13g2_fill_2
X_6660_ _6660_/Y _6660_/A _6660_/B VPWR VGND sg13g2_nand2_1
XFILLER_32_775 VPWR VGND sg13g2_fill_2
X_6591_ _6591_/Y _9429_/Q _6671_/B VPWR VGND sg13g2_nand2_1
X_5611_ _8658_/D _5610_/Y _5609_/Y _5623_/B1 VPWR VGND sg13g2_a21oi_1
X_5542_ _8635_/D _5541_/Y _5540_/Y _6546_/D VPWR VGND sg13g2_a21oi_1
X_8330_ _9165_/D _8344_/A1 _8074_/Y _8329_/Y VPWR VGND sg13g2_o21ai_1
X_9471__2909 _9471_/RESET_B VPWR VGND sg13g2_tiehi
XFILLER_69_0 VPWR VGND sg13g2_decap_4
X_8261_ _8261_/Y _8261_/A _8279_/B VPWR VGND sg13g2_nand2_1
X_5473_ _5474_/A _4387_/Y _8695_/Q _8696_/Q _4388_/X VPWR VGND sg13g2_a22oi_1
XFILLER_99_720 VPWR VGND sg13g2_decap_8
X_7212_ _7212_/Y _7238_/A1 _7210_/Y _7211_/Y VPWR VGND sg13g2_a21oi_1
X_4424_ _6323_/C _6451_/B _8446_/B _6333_/B VPWR VGND sg13g2_nor3_1
X_8192_ _9096_/D _5836_/D _8056_/Y _8191_/Y VPWR VGND sg13g2_o21ai_1
XFILLER_99_742 VPWR VGND sg13g2_decap_8
X_4355_ _5491_/B _9685_/Q _9689_/Q VPWR VGND sg13g2_nor2_1
X_7143_ _7143_/Y _8029_/D _6977_/Y _7132_/Y _4436_/C VPWR VGND sg13g2_a22oi_1
XFILLER_113_563 VPWR VGND sg13g2_fill_2
XFILLER_59_628 VPWR VGND sg13g2_fill_2
X_7074_ _7074_/Y _7172_/A _7172_/B _7080_/C VPWR VGND sg13g2_nand3_1
XFILLER_48_19 VPWR VGND sg13g2_fill_2
XFILLER_101_758 VPWR VGND sg13g2_decap_8
XFILLER_86_447 VPWR VGND sg13g2_decap_4
XFILLER_104_14 VPWR VGND sg13g2_decap_4
XFILLER_86_469 VPWR VGND sg13g2_decap_8
X_6025_ _6041_/B _6338_/B _6033_/C _6033_/D VPWR VGND sg13g2_nor3_1
XFILLER_94_480 VPWR VGND sg13g2_decap_4
XFILLER_67_672 VPWR VGND sg13g2_decap_8
XFILLER_66_171 VPWR VGND sg13g2_decap_8
XFILLER_70_804 VPWR VGND sg13g2_fill_1
XFILLER_54_322 VPWR VGND sg13g2_fill_1
XFILLER_27_547 VPWR VGND sg13g2_fill_2
XFILLER_54_366 VPWR VGND sg13g2_fill_2
X_7976_ _8998_/D _5352_/C _7975_/A _7975_/Y VPWR VGND sg13g2_o21ai_1
XFILLER_120_35 VPWR VGND sg13g2_decap_8
X_6927_ _6927_/Y _9698_/Q _9629_/Q VPWR VGND sg13g2_nor2_1
X_9646_ _9646_/Q _9649_/CLK _9646_/D fanout973/X VPWR VGND sg13g2_dfrbpq_1
X_6858_ _9595_/D _6857_/X _9595_/Q _6906_/S VPWR VGND sg13g2_mux2_1
X_5809_ _9297_/D _5809_/A VPWR VGND sg13g2_inv_1
X_9577_ _9577_/Q _9582_/CLK _9577_/D _9577_/RESET_B VPWR VGND sg13g2_dfrbpq_1
XFILLER_109_803 VPWR VGND sg13g2_fill_2
X_8528_ _8528_/X _8532_/B _8528_/B _8528_/C _8528_/D VPWR VGND sg13g2_and4_1
X_6789_ _9547_/D _9547_/Q _4606_/C _6791_/B VPWR VGND sg13g2_mux2_1
XFILLER_108_335 VPWR VGND sg13g2_fill_1
X_8459_ _9234_/D _8458_/A _5348_/C _8458_/Y VPWR VGND sg13g2_o21ai_1
XFILLER_123_338 VPWR VGND sg13g2_fill_1
XFILLER_104_530 VPWR VGND sg13g2_fill_1
XFILLER_89_296 VPWR VGND sg13g2_decap_8
XFILLER_49_127 VPWR VGND sg13g2_decap_8
Xfanout950 fanout950/X fanout956/X VPWR VGND sg13g2_buf_1
Xfanout961 fanout961/X fanout985/X VPWR VGND sg13g2_buf_1
Xfanout983 fanout983/X fanout984/X VPWR VGND sg13g2_buf_1
Xfanout972 fanout972/X fanout985/X VPWR VGND sg13g2_buf_1
XFILLER_73_642 VPWR VGND sg13g2_fill_1
XFILLER_57_182 VPWR VGND sg13g2_decap_4
XFILLER_73_686 VPWR VGND sg13g2_decap_8
XFILLER_72_141 VPWR VGND sg13g2_decap_4
XFILLER_60_358 VPWR VGND sg13g2_decap_4
XFILLER_54_95 VPWR VGND sg13g2_fill_1
XFILLER_14_764 VPWR VGND sg13g2_decap_8
Xclkload26 clkload26/X clkload26/A VPWR VGND sg13g2_buf_16
Xclkload15 clkload15/Y _9406_/CLK VPWR VGND sg13g2_inv_2
XFILLER_9_289 VPWR VGND sg13g2_fill_1
Xclkload37 clkload37/Y _9588_/CLK VPWR VGND sg13g2_inv_8
XFILLER_110_533 VPWR VGND sg13g2_decap_8
XFILLER_96_778 VPWR VGND sg13g2_decap_4
XFILLER_68_458 VPWR VGND sg13g2_decap_8
XFILLER_95_80 VPWR VGND sg13g2_fill_1
XFILLER_83_439 VPWR VGND sg13g2_decap_8
X_7830_ _8925_/D _8925_/Q _7829_/Y _7830_/S VPWR VGND sg13g2_mux2_1
XFILLER_36_344 VPWR VGND sg13g2_decap_8
X_9525__2855 _9525_/RESET_B VPWR VGND sg13g2_tiehi
XFILLER_64_675 VPWR VGND sg13g2_decap_8
XFILLER_63_141 VPWR VGND sg13g2_fill_2
XFILLER_24_506 VPWR VGND sg13g2_decap_8
X_7761_ _7761_/X _7803_/A _7799_/B _8985_/Q VPWR VGND sg13g2_or3_1
XFILLER_51_347 VPWR VGND sg13g2_fill_2
X_4973_ _4974_/C _4812_/Y _5012_/D _5000_/B1 VPWR VGND sg13g2_a21o_1
X_6712_ _9480_/D _9521_/Q _9480_/Q _6736_/S VPWR VGND sg13g2_mux2_1
X_7692_ _7692_/Y _7692_/A _7692_/B _7692_/C _7692_/D VPWR VGND sg13g2_nor4_1
X_9500_ _9500_/Q clkload6/A _9500_/D _9500_/RESET_B VPWR VGND sg13g2_dfrbpq_1
X_6643_ _6643_/Y _8646_/Q _6666_/A2 _6642_/X VPWR VGND sg13g2_o21ai_1
X_9431_ _9431_/Q _9567_/CLK _9431_/D fanout981/X VPWR VGND sg13g2_dfrbpq_1
XFILLER_32_572 VPWR VGND sg13g2_decap_8
Xclkload9 clkload9/Y clkload9/A VPWR VGND sg13g2_inv_2
X_6574_ _6574_/Y _6574_/A _6587_/B VPWR VGND sg13g2_nand2_1
X_9362_ _9362_/Q _9406_/CLK _9362_/D place2491/X VPWR VGND sg13g2_dfrbpq_1
X_9293_ _9293_/Q _9305_/CLK _9293_/D place2395/X VPWR VGND sg13g2_dfrbpq_1
XFILLER_118_666 VPWR VGND sg13g2_fill_2
XFILLER_117_121 VPWR VGND sg13g2_decap_4
X_5525_ _5525_/Y _5525_/A _5525_/B _8631_/Q _5525_/D VPWR VGND sg13g2_nand4_1
X_8313_ _8313_/Y _9157_/Q _8347_/B VPWR VGND sg13g2_nand2_1
XFILLER_117_154 VPWR VGND sg13g2_decap_8
XFILLER_105_316 VPWR VGND sg13g2_decap_4
X_5456_ _8686_/D _5456_/A _5468_/B_N VPWR VGND sg13g2_nor2b_1
X_8244_ _9122_/D _8244_/A1 _8042_/Y _8243_/Y VPWR VGND sg13g2_o21ai_1
XFILLER_117_198 VPWR VGND sg13g2_decap_4
Xoutput2674 master_addr_o[21] _9879_/X VPWR VGND sg13g2_buf_1
Xoutput2663 master_addr_o[11] _9869_/X VPWR VGND sg13g2_buf_1
X_4407_ _8666_/D _4407_/A _6737_/C VPWR VGND sg13g2_nor2b_1
X_5387_ _5388_/B _8750_/Q _5387_/B VPWR VGND sg13g2_nand2_1
Xoutput2685 master_addr_o[31] _9889_/X VPWR VGND sg13g2_buf_1
Xoutput2696 master_be_o[3] _5055_/Y VPWR VGND sg13g2_buf_1
X_8175_ _8175_/Y _9088_/Q _8197_/B VPWR VGND sg13g2_nand2_1
X_4338_ _8714_/D _8707_/Q VPWR VGND sg13g2_inv_1
XFILLER_59_414 VPWR VGND sg13g2_fill_1
X_7126_ _7126_/Y _7232_/B _7221_/B _7129_/C VPWR VGND sg13g2_nand3_1
X_7057_ _8839_/D _7059_/A _7055_/Y _7056_/Y VPWR VGND sg13g2_o21ai_1
XFILLER_55_620 VPWR VGND sg13g2_decap_8
X_6008_ _9339_/D _9339_/Q _6037_/C _8820_/D VPWR VGND sg13g2_mux2_1
XFILLER_39_193 VPWR VGND sg13g2_fill_1
XFILLER_54_163 VPWR VGND sg13g2_decap_8
XFILLER_54_152 VPWR VGND sg13g2_decap_8
XFILLER_91_27 VPWR VGND sg13g2_decap_8
X_7959_ _7959_/Y _7979_/A _8990_/Q _8353_/C VPWR VGND sg13g2_nand3_1
XFILLER_70_678 VPWR VGND sg13g2_decap_8
XFILLER_30_509 VPWR VGND sg13g2_decap_8
XFILLER_11_701 VPWR VGND sg13g2_fill_2
X_9629_ _9629_/Q _9630_/CLK _9629_/D fanout951/X VPWR VGND sg13g2_dfrbpq_1
XFILLER_7_705 VPWR VGND sg13g2_fill_1
XFILLER_11_789 VPWR VGND sg13g2_fill_1
XFILLER_7_738 VPWR VGND sg13g2_decap_8
XFILLER_10_288 VPWR VGND sg13g2_decap_4
X_9575__2815 _9575_/RESET_B VPWR VGND sg13g2_tiehi
XFILLER_108_198 VPWR VGND sg13g2_decap_4
XFILLER_123_168 VPWR VGND sg13g2_decap_8
XFILLER_77_222 VPWR VGND sg13g2_fill_2
XFILLER_2_498 VPWR VGND sg13g2_decap_8
XFILLER_1_14 VPWR VGND sg13g2_decap_8
XFILLER_93_748 VPWR VGND sg13g2_decap_8
XFILLER_77_277 VPWR VGND sg13g2_fill_2
XFILLER_77_266 VPWR VGND sg13g2_decap_8
XFILLER_93_759 VPWR VGND sg13g2_fill_2
XFILLER_18_311 VPWR VGND sg13g2_decap_8
XFILLER_18_322 VPWR VGND sg13g2_fill_1
XFILLER_92_269 VPWR VGND sg13g2_decap_8
XFILLER_73_483 VPWR VGND sg13g2_decap_8
XFILLER_45_185 VPWR VGND sg13g2_fill_2
XFILLER_60_133 VPWR VGND sg13g2_fill_2
XFILLER_33_347 VPWR VGND sg13g2_decap_8
XFILLER_81_60 VPWR VGND sg13g2_decap_8
XFILLER_61_689 VPWR VGND sg13g2_decap_8
XFILLER_60_177 VPWR VGND sg13g2_decap_8
XFILLER_14_561 VPWR VGND sg13g2_decap_8
XFILLER_14_583 VPWR VGND sg13g2_decap_4
XFILLER_41_380 VPWR VGND sg13g2_fill_1
Xplace1916 _8563_/B _7028_/C VPWR VGND sg13g2_buf_1
X_5310_ _5371_/C _5319_/A _9498_/Q VPWR VGND sg13g2_nand2_1
Xplace1927 _6312_/A _6470_/A2 VPWR VGND sg13g2_buf_1
Xplace1905 _6373_/A1 _6379_/A1 VPWR VGND sg13g2_buf_1
X_6290_ _9369_/D _6285_/Y _6288_/Y _6289_/Y VPWR VGND sg13g2_a21oi_1
XFILLER_114_135 VPWR VGND sg13g2_decap_8
Xplace1938 _7737_/B1 _6994_/Y VPWR VGND sg13g2_buf_1
Xplace1949 _6411_/A2 _6130_/B VPWR VGND sg13g2_buf_1
X_5241_ _5244_/A _5242_/B _5242_/C _5242_/A VPWR VGND sg13g2_o21ai_1
XFILLER_123_680 VPWR VGND sg13g2_decap_8
XFILLER_96_520 VPWR VGND sg13g2_fill_1
X_5172_ _5351_/C _8089_/A _9478_/Q VPWR VGND sg13g2_nand2_1
XFILLER_68_255 VPWR VGND sg13g2_fill_2
XFILLER_110_363 VPWR VGND sg13g2_fill_1
XFILLER_68_266 VPWR VGND sg13g2_fill_1
X_8931_ _8931_/Q _9198_/CLK _8931_/D place2452/X VPWR VGND sg13g2_dfrbpq_1
XFILLER_71_409 VPWR VGND sg13g2_fill_1
X_8862_ _8862_/Q _9407_/CLK _8862_/D place2455/X VPWR VGND sg13g2_dfrbpq_1
XFILLER_92_781 VPWR VGND sg13g2_decap_4
X_8793_ _8793_/Q _9252_/CLK _8793_/D place2403/X VPWR VGND sg13g2_dfrbpq_1
XFILLER_51_100 VPWR VGND sg13g2_decap_8
X_7813_ _7817_/D _9112_/Q _4497_/Y _7822_/A VPWR VGND sg13g2_o21ai_1
X_7744_ _7744_/Y _7744_/A _7744_/B _7744_/C _7744_/D VPWR VGND sg13g2_nor4_1
XFILLER_52_678 VPWR VGND sg13g2_fill_2
X_4956_ _4960_/A _4953_/Y _4955_/X _4957_/D VPWR VGND sg13g2_a21o_1
X_7675_ _7676_/D _9218_/Q _7695_/A2 _6972_/Y _8885_/Q VPWR VGND sg13g2_a22oi_1
X_4887_ _4887_/Y _4887_/A _4887_/B VPWR VGND sg13g2_nor2_1
X_6626_ _6626_/Y _6642_/C _8641_/Q _9573_/Q _6655_/B2 VPWR VGND sg13g2_a22oi_1
X_9414_ _9414_/Q _9414_/CLK _9414_/D place2500/X VPWR VGND sg13g2_dfrbpq_1
XFILLER_20_564 VPWR VGND sg13g2_fill_2
X_9345_ _9345_/Q _9414_/CLK _9345_/D place2502/X VPWR VGND sg13g2_dfrbpq_1
X_6557_ _9420_/D _8661_/Q _6544_/Y _6556_/X VPWR VGND sg13g2_a21o_1
X_5508_ _5508_/Y _9422_/Q _5615_/B _5523_/B1 _8624_/Q VPWR VGND sg13g2_a22oi_1
XFILLER_106_647 VPWR VGND sg13g2_decap_8
X_9276_ _9276_/Q _9305_/CLK _9276_/D place2407/X VPWR VGND sg13g2_dfrbpq_1
X_6488_ _6488_/Y _4425_/Y _6298_/Y _6399_/D VPWR VGND sg13g2_o21ai_1
XFILLER_105_168 VPWR VGND sg13g2_decap_4
XFILLER_10_56 VPWR VGND sg13g2_fill_2
X_5439_ _5440_/A _5439_/A1 _8678_/Q _8679_/Q _5451_/B2 VPWR VGND sg13g2_a22oi_1
X_8227_ _8227_/Y _8227_/A _8251_/B VPWR VGND sg13g2_nand2_1
XFILLER_86_27 VPWR VGND sg13g2_fill_2
X_8158_ _9079_/D _8160_/A1 _8095_/Y _8157_/Y VPWR VGND sg13g2_o21ai_1
XFILLER_59_211 VPWR VGND sg13g2_fill_1
XFILLER_101_330 VPWR VGND sg13g2_decap_8
XFILLER_87_564 VPWR VGND sg13g2_fill_2
X_7109_ _7109_/Y _5367_/C _7127_/A2 _7108_/Y VPWR VGND sg13g2_o21ai_1
XFILLER_87_575 VPWR VGND sg13g2_decap_8
X_8089_ _8089_/Y _8089_/A _9496_/Q _8092_/C _8095_/D VPWR VGND sg13g2_nand4_1
XFILLER_74_214 VPWR VGND sg13g2_decap_8
XFILLER_19_87 VPWR VGND sg13g2_decap_8
XFILLER_62_409 VPWR VGND sg13g2_fill_1
XFILLER_27_141 VPWR VGND sg13g2_fill_2
XFILLER_28_664 VPWR VGND sg13g2_decap_8
XFILLER_83_781 VPWR VGND sg13g2_fill_1
XFILLER_35_42 VPWR VGND sg13g2_fill_2
XFILLER_35_53 VPWR VGND sg13g2_decap_8
XFILLER_35_86 VPWR VGND sg13g2_decap_4
XFILLER_42_188 VPWR VGND sg13g2_fill_2
XFILLER_7_557 VPWR VGND sg13g2_decap_8
XFILLER_109_463 VPWR VGND sg13g2_decap_8
XFILLER_7_568 VPWR VGND sg13g2_fill_2
XFILLER_2_284 VPWR VGND sg13g2_fill_2
XFILLER_78_586 VPWR VGND sg13g2_fill_1
XFILLER_66_759 VPWR VGND sg13g2_fill_2
Xclkbuf_3_2__f_clk_i clkbuf_3_2__f_clk_i/X clkbuf_0_clk_i/X VPWR VGND sg13g2_buf_8
XFILLER_93_578 VPWR VGND sg13g2_fill_1
XFILLER_18_163 VPWR VGND sg13g2_fill_1
XFILLER_33_122 VPWR VGND sg13g2_fill_2
X_4810_ _4810_/Y _4928_/B _4928_/C _4813_/A VPWR VGND sg13g2_a21oi_1
X_5790_ _5791_/A _9288_/Q _8585_/A2 _8585_/B1 _9485_/Q VPWR VGND sg13g2_a22oi_1
XFILLER_21_317 VPWR VGND sg13g2_fill_1
XFILLER_33_166 VPWR VGND sg13g2_fill_2
X_4741_ _9691_/D _4740_/Y _4455_/B _4739_/X VPWR VGND sg13g2_o21ai_1
X_4672_ _4672_/X _4675_/A _4674_/B VPWR VGND sg13g2_or2_1
X_7460_ _8906_/D _8906_/Q _7459_/Y _7830_/S VPWR VGND sg13g2_mux2_1
Xplace2403 place2403/X place2422/X VPWR VGND sg13g2_buf_1
X_6411_ _6411_/Y _8877_/Q _6411_/A2 _6408_/Y _6410_/Y _6406_/Y VPWR VGND sg13g2_a221oi_1
Xplace2447 place2447/X place2448/X VPWR VGND sg13g2_buf_1
Xplace2414 place2414/X place2415/X VPWR VGND sg13g2_buf_1
X_7391_ _7395_/A _8791_/Q _7824_/B _7640_/A2 _9865_/A VPWR VGND sg13g2_a22oi_1
Xplace2425 place2425/X place2426/X VPWR VGND sg13g2_buf_1
Xplace2436 place2436/X place2453/X VPWR VGND sg13g2_buf_1
X_9130_ _9130_/Q _9501_/CLK _9130_/D place2470/X VPWR VGND sg13g2_dfrbpq_1
Xplace2458 place2458/X place2459/X VPWR VGND sg13g2_buf_1
X_6342_ _9376_/D _6342_/A _6342_/B _6342_/C VPWR VGND sg13g2_nand3_1
Xplace2469 place2469/X place2473/X VPWR VGND sg13g2_buf_1
XFILLER_115_466 VPWR VGND sg13g2_decap_8
Xhold3105 _4405_/A _8667_/Q VPWR VGND sg13g2_dlygate4sd3_1
X_9061_ _9061_/Q _9188_/CLK _9061_/D place2483/X VPWR VGND sg13g2_dfrbpq_1
X_6273_ _6273_/Y _6273_/A _6273_/B _6273_/C VPWR VGND sg13g2_nor3_1
XFILLER_102_127 VPWR VGND sg13g2_decap_8
Xplace1779 _8560_/B1 _8519_/Y VPWR VGND sg13g2_buf_1
Xhold3138 _7419_/A _8905_/Q VPWR VGND sg13g2_dlygate4sd3_1
X_8012_ _9016_/D _5370_/C _8011_/A _8011_/Y VPWR VGND sg13g2_o21ai_1
X_5224_ _5224_/Y _5224_/A _5224_/B VPWR VGND sg13g2_nand2_1
Xhold3127 _8103_/A _9052_/Q VPWR VGND sg13g2_dlygate4sd3_1
Xhold3116 _8131_/A _9066_/Q VPWR VGND sg13g2_dlygate4sd3_1
Xhold3149 _8177_/A _9089_/Q VPWR VGND sg13g2_dlygate4sd3_1
XFILLER_84_501 VPWR VGND sg13g2_fill_1
X_5155_ _5350_/C _8399_/C _9477_/Q VPWR VGND sg13g2_nand2_1
X_5086_ _5736_/A _5086_/A _5086_/B _9858_/A _5110_/A VPWR VGND sg13g2_nand4_1
X_8914_ _8914_/Q _9611_/CLK _8914_/D place2416/X VPWR VGND sg13g2_dfrbpq_1
XFILLER_84_589 VPWR VGND sg13g2_decap_4
X_8845_ _8845_/Q _9242_/CLK _8845_/D place2492/X VPWR VGND sg13g2_dfrbpq_1
XFILLER_37_483 VPWR VGND sg13g2_fill_1
XFILLER_37_494 VPWR VGND sg13g2_fill_2
XFILLER_52_431 VPWR VGND sg13g2_decap_8
XFILLER_24_133 VPWR VGND sg13g2_decap_4
X_5988_ _9331_/D _5987_/Y _9331_/Q _6006_/S VPWR VGND sg13g2_mux2_1
X_8776_ _9882_/A _9260_/CLK _8776_/D place2394/X VPWR VGND sg13g2_dfrbpq_1
XFILLER_52_464 VPWR VGND sg13g2_decap_8
XFILLER_12_306 VPWR VGND sg13g2_decap_4
X_7727_ _7727_/Y _7727_/A _7727_/B _7727_/C _7727_/D VPWR VGND sg13g2_nor4_1
X_4939_ _4939_/Y _4928_/B _4939_/A2 _4812_/Y _4938_/Y _4772_/A VPWR VGND sg13g2_a221oi_1
X_7658_ _8916_/D _8916_/Q _7657_/Y _7774_/S VPWR VGND sg13g2_mux2_1
X_6609_ _9434_/D _6663_/A1 _6608_/Y _6606_/Y VPWR VGND sg13g2_o21ai_1
XFILLER_20_361 VPWR VGND sg13g2_fill_2
X_7589_ _7589_/Y _9069_/Q _7799_/B _7759_/A VPWR VGND sg13g2_nand3b_1
X_9328_ _9328_/Q _9410_/CLK _9328_/D place2397/X VPWR VGND sg13g2_dfrbpq_1
XFILLER_21_66 VPWR VGND sg13g2_decap_4
X_9259_ _9259_/Q _9260_/CLK _9259_/D place2407/X VPWR VGND sg13g2_dfrbpq_1
XFILLER_79_306 VPWR VGND sg13g2_fill_1
XFILLER_106_477 VPWR VGND sg13g2_decap_8
XFILLER_0_700 VPWR VGND sg13g2_fill_2
X_9520__2860 _9520_/RESET_B VPWR VGND sg13g2_tiehi
XFILLER_87_350 VPWR VGND sg13g2_fill_2
XFILLER_101_182 VPWR VGND sg13g2_fill_1
XFILLER_87_383 VPWR VGND sg13g2_fill_2
Xhold2971 _6504_/B1 _9405_/Q VPWR VGND sg13g2_dlygate4sd3_1
Xhold2993 _6084_/B1 _9347_/Q VPWR VGND sg13g2_dlygate4sd3_1
Xhold2960 _4572_/B _9700_/Q VPWR VGND sg13g2_dlygate4sd3_1
Xhold2982 _6244_/B1 _9365_/Q VPWR VGND sg13g2_dlygate4sd3_1
XFILLER_47_258 VPWR VGND sg13g2_decap_8
XFILLER_90_537 VPWR VGND sg13g2_decap_4
XFILLER_62_228 VPWR VGND sg13g2_decap_8
XFILLER_28_461 VPWR VGND sg13g2_decap_4
XFILLER_15_111 VPWR VGND sg13g2_decap_8
XFILLER_15_122 VPWR VGND sg13g2_fill_2
XFILLER_71_773 VPWR VGND sg13g2_fill_2
XFILLER_30_169 VPWR VGND sg13g2_decap_8
XFILLER_117_709 VPWR VGND sg13g2_decap_4
XFILLER_7_35 VPWR VGND sg13g2_decap_8
XFILLER_98_615 VPWR VGND sg13g2_fill_2
XFILLER_98_648 VPWR VGND sg13g2_decap_8
XFILLER_66_545 VPWR VGND sg13g2_decap_8
XFILLER_66_589 VPWR VGND sg13g2_decap_4
X_6960_ _6960_/Y _7644_/B _7244_/D _6972_/C VPWR VGND sg13g2_nor3_1
XFILLER_54_707 VPWR VGND sg13g2_decap_4
X_5911_ _9315_/D _5910_/Y _5935_/A2 _5904_/Y VPWR VGND sg13g2_o21ai_1
XFILLER_53_228 VPWR VGND sg13g2_decap_8
XFILLER_19_472 VPWR VGND sg13g2_decap_8
X_6891_ _6891_/X _8919_/Q _8951_/Q _6901_/S VPWR VGND sg13g2_mux2_1
XFILLER_62_740 VPWR VGND sg13g2_fill_1
X_5842_ _5842_/X _5769_/B _5842_/A2 _5049_/Y VPWR VGND sg13g2_a21o_1
X_8630_ _8630_/Q _9645_/CLK _8630_/D fanout968/X VPWR VGND sg13g2_dfrbpq_1
XFILLER_22_615 VPWR VGND sg13g2_fill_1
XFILLER_34_453 VPWR VGND sg13g2_decap_8
X_8561_ _9273_/D _8561_/A VPWR VGND sg13g2_inv_1
X_5773_ _5773_/X _9314_/Q _9330_/Q _9306_/Q _9322_/Q _5050_/Y _5085_/Y VPWR VGND sg13g2_mux4_1
X_4724_ _4724_/Y _8741_/Q _9684_/Q VPWR VGND sg13g2_nor2b_1
X_7512_ _7515_/B _7506_/Y _7511_/Y _7512_/B1 VPWR VGND sg13g2_o21ai_1
X_9570__2820 _9570_/RESET_B VPWR VGND sg13g2_tiehi
XFILLER_108_709 VPWR VGND sg13g2_decap_4
X_8492_ _8492_/Y _8492_/A _8492_/B _8492_/C VPWR VGND sg13g2_nand3_1
X_4655_ _4655_/Y _9646_/Q _8717_/Q _9649_/Q _6953_/S VPWR VGND sg13g2_a22oi_1
X_7443_ _7458_/A _9284_/Q _5785_/C _7826_/A2 _9316_/Q _7442_/Y VPWR VGND sg13g2_a221oi_1
Xplace2211 _5597_/B _5525_/B VPWR VGND sg13g2_buf_1
Xplace2222 _7245_/C _9467_/Q VPWR VGND sg13g2_buf_1
Xplace2200 _5468_/B_N _5472_/B_N VPWR VGND sg13g2_buf_1
XFILLER_116_731 VPWR VGND sg13g2_fill_1
Xplace2244 _7759_/A _7803_/A VPWR VGND sg13g2_buf_1
Xplace2233 _5827_/A _7704_/A VPWR VGND sg13g2_buf_1
X_4586_ _4590_/A _9698_/Q _9706_/Q VPWR VGND sg13g2_or2_1
Xplace2255 _7469_/A _7296_/C VPWR VGND sg13g2_buf_1
X_7374_ _7376_/C _8839_/Q _7598_/A2 _7598_/B1 _8870_/Q VPWR VGND sg13g2_a22oi_1
Xplace2277 _7705_/B _7644_/B VPWR VGND sg13g2_buf_1
Xplace2266 _7831_/A _7608_/B VPWR VGND sg13g2_buf_1
X_9113_ _9113_/Q _9501_/CLK _9113_/D place2468/X VPWR VGND sg13g2_dfrbpq_1
Xplace2288 _4995_/S _9341_/Q VPWR VGND sg13g2_buf_1
X_6325_ _6325_/Y _6325_/A1 _6324_/Y _6229_/B VPWR VGND sg13g2_o21ai_1
X_9044_ _9044_/Q _9199_/CLK _9044_/D place2424/X VPWR VGND sg13g2_dfrbpq_1
Xplace2299 _4793_/B _4820_/B VPWR VGND sg13g2_buf_1
XFILLER_103_458 VPWR VGND sg13g2_decap_8
X_6256_ _6256_/X _8982_/Q _9044_/Q _9106_/Q _9168_/Q _6514_/S0 _6514_/S1 VPWR VGND
+ sg13g2_mux4_1
X_5207_ _5207_/Y _5207_/A _5207_/B VPWR VGND sg13g2_nand2_1
X_6187_ _9356_/D _6253_/S _6186_/Y _6185_/Y VPWR VGND sg13g2_o21ai_1
XFILLER_123_35 VPWR VGND sg13g2_decap_8
X_5138_ _5138_/Y _5090_/Y _5134_/Y _5135_/Y VPWR VGND sg13g2_o21ai_1
XFILLER_57_567 VPWR VGND sg13g2_decap_4
X_5069_ _5376_/B _6534_/A _6534_/B _5070_/C _8750_/Q VPWR VGND sg13g2_nor4_1
X_9877_ _9877_/X _9877_/A VPWR VGND sg13g2_buf_1
X_8828_ _8828_/Q _9504_/CLK _8828_/D place2428/X VPWR VGND sg13g2_dfrbpq_1
XFILLER_52_261 VPWR VGND sg13g2_fill_2
XFILLER_25_486 VPWR VGND sg13g2_fill_2
X_8759_ _9865_/A _9219_/CLK _8759_/D place2408/X VPWR VGND sg13g2_dfrbpq_1
XFILLER_80_581 VPWR VGND sg13g2_fill_1
XFILLER_53_795 VPWR VGND sg13g2_fill_1
XFILLER_52_294 VPWR VGND sg13g2_decap_4
XFILLER_12_136 VPWR VGND sg13g2_fill_2
X_9538__2842 _9538_/RESET_B VPWR VGND sg13g2_tiehi
XFILLER_8_129 VPWR VGND sg13g2_decap_8
Xclkbuf_leaf_15_clk_i _9410_/CLK clkload3/A VPWR VGND sg13g2_buf_16
XFILLER_107_742 VPWR VGND sg13g2_fill_2
XFILLER_122_767 VPWR VGND sg13g2_decap_4
XFILLER_94_117 VPWR VGND sg13g2_fill_1
XFILLER_75_342 VPWR VGND sg13g2_decap_8
XFILLER_63_515 VPWR VGND sg13g2_decap_8
XFILLER_90_345 VPWR VGND sg13g2_decap_8
XFILLER_16_442 VPWR VGND sg13g2_decap_8
XFILLER_16_497 VPWR VGND sg13g2_fill_1
XFILLER_8_641 VPWR VGND sg13g2_decap_4
XFILLER_7_151 VPWR VGND sg13g2_decap_8
X_4440_ _4447_/B _4440_/A _4440_/B VPWR VGND sg13g2_nand2_1
XFILLER_7_195 VPWR VGND sg13g2_decap_8
X_4371_ _6686_/B _4481_/C _4481_/A _9653_/Q VPWR VGND sg13g2_a21oi_1
XFILLER_98_423 VPWR VGND sg13g2_fill_2
X_6110_ _6110_/Y _6379_/A1 _6346_/B _6110_/B1 VPWR VGND sg13g2_a21oi_1
XFILLER_113_756 VPWR VGND sg13g2_decap_8
X_7090_ _7090_/Y _7191_/A _7210_/D _7123_/C VPWR VGND sg13g2_nand3_1
XFILLER_113_789 VPWR VGND sg13g2_fill_2
XFILLER_113_778 VPWR VGND sg13g2_decap_8
XFILLER_100_417 VPWR VGND sg13g2_fill_2
X_6041_ _6042_/C _6041_/A _6041_/B _6049_/A _6043_/B VPWR VGND sg13g2_nand4_1
XFILLER_39_534 VPWR VGND sg13g2_decap_8
X_9588__2802 _9588_/RESET_B VPWR VGND sg13g2_tiehi
XFILLER_14_0 VPWR VGND sg13g2_decap_8
XFILLER_93_161 VPWR VGND sg13g2_decap_8
XFILLER_26_217 VPWR VGND sg13g2_decap_4
X_7992_ _9006_/D _5360_/C _8019_/A _7991_/Y VPWR VGND sg13g2_o21ai_1
XFILLER_54_548 VPWR VGND sg13g2_fill_2
X_6943_ _6945_/B _6943_/A _6951_/B VPWR VGND sg13g2_nor2_1
XFILLER_35_740 VPWR VGND sg13g2_fill_1
X_9662_ _9662_/Q _9662_/CLK _9662_/D place2447/X VPWR VGND sg13g2_dfrbpq_1
X_6874_ _9603_/D _6873_/X _9603_/Q _6900_/S VPWR VGND sg13g2_mux2_1
X_5825_ _9305_/D _5825_/A VPWR VGND sg13g2_inv_1
XFILLER_62_592 VPWR VGND sg13g2_decap_8
X_8613_ _8613_/Q _9689_/CLK _8613_/D fanout961/X VPWR VGND sg13g2_dfrbpq_1
X_9593_ _9593_/Q _9620_/CLK _9593_/D _9593_/RESET_B VPWR VGND sg13g2_dfrbpq_1
X_8544_ _8544_/Y _8536_/Y _8544_/B _9265_/Q VPWR VGND sg13g2_nand3b_1
X_5756_ _5756_/Y _5772_/A1 _5754_/Y _5755_/Y VPWR VGND sg13g2_a21oi_1
X_4707_ _4708_/B _9671_/Q _4707_/B VPWR VGND sg13g2_nor2_1
X_8475_ _9242_/D _8474_/A _5356_/C _8474_/Y VPWR VGND sg13g2_o21ai_1
X_5687_ _5688_/A _5689_/B2 _5693_/A2 _5693_/B1 _5687_/B2 VPWR VGND sg13g2_a22oi_1
X_4638_ _4640_/B _9458_/Q _9457_/Q _4652_/A VPWR VGND sg13g2_o21ai_1
Xplace2030 _6669_/B2 _6566_/Y VPWR VGND sg13g2_buf_1
X_7426_ _7429_/B _7486_/A _7492_/B _8968_/Q VPWR VGND sg13g2_nor3_1
Xplace2052 _5589_/B1 _5586_/B1 VPWR VGND sg13g2_buf_1
Xplace2041 _8190_/A1 _5836_/D VPWR VGND sg13g2_buf_1
Xplace2063 _8350_/A1 _7028_/D VPWR VGND sg13g2_buf_1
Xplace2085 _5952_/A _5771_/A1 VPWR VGND sg13g2_buf_1
XFILLER_103_200 VPWR VGND sg13g2_decap_8
Xplace2096 _5740_/A2 _5083_/A VPWR VGND sg13g2_buf_1
X_4569_ _4569_/Y _4569_/A _8728_/Q VPWR VGND sg13g2_nor2b_1
XFILLER_78_39 VPWR VGND sg13g2_decap_8
X_7357_ _7358_/B _8789_/Q _7824_/B _7640_/A2 _9863_/A VPWR VGND sg13g2_a22oi_1
Xplace2074 _5373_/D _6994_/D VPWR VGND sg13g2_buf_1
XFILLER_116_594 VPWR VGND sg13g2_decap_8
XFILLER_89_456 VPWR VGND sg13g2_fill_2
X_7288_ _7288_/Y _7282_/Y _7287_/Y _5377_/X VPWR VGND sg13g2_a21oi_1
X_6308_ _6308_/Y _6325_/A1 _6307_/Y _6229_/B VPWR VGND sg13g2_o21ai_1
X_6239_ _6273_/A _6397_/B _6103_/B _6271_/A VPWR VGND sg13g2_a21oi_1
X_9027_ _9027_/Q _9183_/CLK _9027_/D place2471/X VPWR VGND sg13g2_dfrbpq_1
XFILLER_76_117 VPWR VGND sg13g2_decap_4
XFILLER_69_191 VPWR VGND sg13g2_decap_8
XFILLER_85_695 VPWR VGND sg13g2_fill_2
XFILLER_17_217 VPWR VGND sg13g2_fill_2
XFILLER_17_228 VPWR VGND sg13g2_fill_1
XFILLER_27_32 VPWR VGND sg13g2_decap_4
XFILLER_45_559 VPWR VGND sg13g2_decap_4
XFILLER_72_389 VPWR VGND sg13g2_fill_1
XFILLER_60_518 VPWR VGND sg13g2_decap_4
XFILLER_25_250 VPWR VGND sg13g2_decap_4
XFILLER_32_209 VPWR VGND sg13g2_decap_8
XFILLER_13_412 VPWR VGND sg13g2_decap_8
XFILLER_41_776 VPWR VGND sg13g2_decap_8
XFILLER_43_97 VPWR VGND sg13g2_fill_1
XFILLER_5_622 VPWR VGND sg13g2_decap_8
XFILLER_99_209 VPWR VGND sg13g2_fill_1
XFILLER_107_550 VPWR VGND sg13g2_fill_2
XFILLER_4_176 VPWR VGND sg13g2_decap_4
XFILLER_4_14 VPWR VGND sg13g2_decap_8
XFILLER_110_759 VPWR VGND sg13g2_fill_2
XFILLER_76_662 VPWR VGND sg13g2_decap_8
XFILLER_91_643 VPWR VGND sg13g2_decap_8
XFILLER_91_632 VPWR VGND sg13g2_fill_2
XFILLER_90_164 VPWR VGND sg13g2_decap_8
XFILLER_17_751 VPWR VGND sg13g2_decap_4
XFILLER_23_209 VPWR VGND sg13g2_fill_2
XFILLER_17_784 VPWR VGND sg13g2_fill_2
XFILLER_32_743 VPWR VGND sg13g2_decap_4
XFILLER_44_581 VPWR VGND sg13g2_decap_8
XFILLER_44_592 VPWR VGND sg13g2_decap_8
XFILLER_31_253 VPWR VGND sg13g2_decap_8
XFILLER_32_754 VPWR VGND sg13g2_fill_2
X_6590_ _9428_/D _6569_/Y _6589_/Y _6587_/Y VPWR VGND sg13g2_o21ai_1
X_5610_ _5610_/Y _8659_/Q _5498_/X _5500_/Y _8658_/Q VPWR VGND sg13g2_a22oi_1
X_5541_ _5541_/Y _9433_/Q _5591_/B _5601_/B1 _8635_/Q VPWR VGND sg13g2_a22oi_1
X_8260_ _9130_/D _8288_/A1 _7925_/Y _8259_/Y VPWR VGND sg13g2_o21ai_1
X_7211_ _7211_/Y _7237_/A1 _9494_/Q _7229_/B1 _7229_/B2 VPWR VGND sg13g2_a22oi_1
X_5472_ _8694_/D _5472_/A _5472_/B_N VPWR VGND sg13g2_nor2b_1
XFILLER_99_710 VPWR VGND sg13g2_decap_4
X_4423_ _6451_/B _9246_/Q _6262_/C VPWR VGND sg13g2_nand2_1
X_8191_ _8191_/Y _8191_/A _8191_/B VPWR VGND sg13g2_nand2_1
X_4354_ _8744_/D _7002_/B _7002_/C _8743_/Q VPWR VGND sg13g2_a21oi_1
X_7142_ _8866_/D _6975_/X _7140_/Y _7141_/Y VPWR VGND sg13g2_o21ai_1
XFILLER_113_553 VPWR VGND sg13g2_fill_2
XFILLER_99_776 VPWR VGND sg13g2_decap_8
X_7073_ _8844_/D _7072_/Y _8844_/Q _7085_/S VPWR VGND sg13g2_mux2_1
XFILLER_101_726 VPWR VGND sg13g2_fill_2
X_6024_ _6024_/Y _6024_/A _6047_/A VPWR VGND sg13g2_nand2_1
XFILLER_86_459 VPWR VGND sg13g2_decap_4
XFILLER_67_651 VPWR VGND sg13g2_decap_8
XFILLER_39_353 VPWR VGND sg13g2_fill_2
XFILLER_104_37 VPWR VGND sg13g2_decap_8
XFILLER_54_301 VPWR VGND sg13g2_decap_4
XFILLER_39_364 VPWR VGND sg13g2_decap_8
XFILLER_82_643 VPWR VGND sg13g2_decap_8
XFILLER_81_120 VPWR VGND sg13g2_decap_8
XFILLER_66_194 VPWR VGND sg13g2_fill_2
XFILLER_54_334 VPWR VGND sg13g2_decap_8
X_7975_ _7975_/Y _7975_/A _8998_/Q _8383_/C VPWR VGND sg13g2_nand3_1
XFILLER_120_14 VPWR VGND sg13g2_decap_8
X_6926_ _6926_/Y _9628_/Q _6937_/B _6939_/C VPWR VGND sg13g2_nand3_1
XFILLER_42_507 VPWR VGND sg13g2_decap_8
XFILLER_82_698 VPWR VGND sg13g2_decap_8
XFILLER_81_197 VPWR VGND sg13g2_fill_1
X_9645_ _9645_/Q _9645_/CLK _9645_/D fanout973/X VPWR VGND sg13g2_dfrbpq_1
X_6857_ _6857_/X _8902_/Q _8934_/Q _6905_/S VPWR VGND sg13g2_mux2_1
X_9576_ _9576_/Q _9582_/CLK _9576_/D _9576_/RESET_B VPWR VGND sg13g2_dfrbpq_1
X_5808_ _5809_/A _9297_/Q _8579_/A2 _8579_/B1 _9494_/Q VPWR VGND sg13g2_a22oi_1
X_6788_ _9546_/D _6788_/A1 _6785_/S _6787_/Y VPWR VGND sg13g2_a21oi_1
X_8527_ _8532_/C _8530_/A _8530_/B _8528_/D _8528_/C VPWR VGND sg13g2_nand4_1
X_5739_ _5739_/Y _5739_/A _9321_/Q VPWR VGND sg13g2_nand2_1
XFILLER_108_347 VPWR VGND sg13g2_fill_2
XFILLER_89_49 VPWR VGND sg13g2_decap_8
X_8458_ _8458_/Y _8458_/A _9234_/Q _8474_/C VPWR VGND sg13g2_nand3_1
X_8389_ _8389_/Y _8403_/A _9195_/Q _8389_/C VPWR VGND sg13g2_nand3_1
X_7409_ _7412_/A _7410_/A _9122_/Q _7832_/C VPWR VGND sg13g2_nor3_1
XFILLER_104_575 VPWR VGND sg13g2_fill_2
X_9488__2892 _9488_/RESET_B VPWR VGND sg13g2_tiehi
Xfanout940 _5954_/C _8530_/D VPWR VGND sg13g2_buf_1
Xfanout951 fanout951/X fanout956/X VPWR VGND sg13g2_buf_1
Xfanout973 fanout973/X fanout975/X VPWR VGND sg13g2_buf_1
Xfanout984 fanout984/X fanout985/X VPWR VGND sg13g2_buf_1
Xfanout962 fanout962/X fanout964/X VPWR VGND sg13g2_buf_1
XFILLER_72_120 VPWR VGND sg13g2_fill_2
XFILLER_73_676 VPWR VGND sg13g2_decap_4
XFILLER_60_304 VPWR VGND sg13g2_decap_8
XFILLER_14_743 VPWR VGND sg13g2_fill_1
XFILLER_13_264 VPWR VGND sg13g2_fill_1
XFILLER_14_776 VPWR VGND sg13g2_fill_2
XFILLER_41_584 VPWR VGND sg13g2_decap_4
XFILLER_70_62 VPWR VGND sg13g2_decap_4
XFILLER_9_246 VPWR VGND sg13g2_fill_1
XFILLER_9_235 VPWR VGND sg13g2_decap_8
XFILLER_70_95 VPWR VGND sg13g2_fill_2
Xclkload16 clkload16/Y _9198_/CLK VPWR VGND sg13g2_inv_1
Xclkload27 clkload27/Y _9686_/CLK VPWR VGND sg13g2_inv_4
XFILLER_5_430 VPWR VGND sg13g2_decap_8
XFILLER_96_702 VPWR VGND sg13g2_decap_8
XFILLER_68_404 VPWR VGND sg13g2_decap_4
XFILLER_68_437 VPWR VGND sg13g2_decap_8
XFILLER_96_757 VPWR VGND sg13g2_decap_8
XFILLER_83_407 VPWR VGND sg13g2_decap_4
XFILLER_83_418 VPWR VGND sg13g2_decap_8
XFILLER_48_194 VPWR VGND sg13g2_fill_2
X_7760_ _7763_/C _9047_/Q _7767_/B VPWR VGND sg13g2_nor2_1
XFILLER_63_175 VPWR VGND sg13g2_decap_4
XFILLER_51_326 VPWR VGND sg13g2_fill_2
X_4972_ _4974_/B _9400_/Q _4972_/B VPWR VGND sg13g2_nand2_1
X_6711_ _9479_/D _9520_/Q _9479_/Q _6714_/S VPWR VGND sg13g2_mux2_1
X_7691_ _7692_/B _9198_/Q _7804_/B _7744_/A VPWR VGND sg13g2_o21ai_1
X_6642_ _6642_/X _6661_/A _9578_/Q _6642_/C VPWR VGND sg13g2_or3_1
X_9430_ _9430_/Q _9449_/CLK _9430_/D fanout981/X VPWR VGND sg13g2_dfrbpq_1
XFILLER_20_713 VPWR VGND sg13g2_decap_8
X_9361_ _9361_/Q _9406_/CLK _9361_/D place2390/X VPWR VGND sg13g2_dfrbpq_1
X_6573_ _9423_/D _6670_/A1 _6572_/Y _6571_/Y VPWR VGND sg13g2_o21ai_1
X_8312_ _9156_/D _7028_/D _8050_/Y _8311_/Y VPWR VGND sg13g2_o21ai_1
X_9292_ _9292_/Q _9305_/CLK _9292_/D place2395/X VPWR VGND sg13g2_dfrbpq_1
X_5524_ _8629_/D _5523_/Y _5522_/Y _5602_/B1 VPWR VGND sg13g2_a21oi_1
XFILLER_9_791 VPWR VGND sg13g2_fill_2
X_5455_ _5456_/A _5455_/A1 _8686_/Q _8687_/Q _5467_/B2 VPWR VGND sg13g2_a22oi_1
X_8243_ _8243_/Y _8243_/A _8243_/B VPWR VGND sg13g2_nand2_1
Xoutput2664 master_addr_o[12] _9870_/X VPWR VGND sg13g2_buf_1
X_8174_ _9087_/D _8198_/A1 _7897_/Y _8173_/Y VPWR VGND sg13g2_o21ai_1
X_4406_ _4407_/A _8666_/Q _5439_/A1 _4405_/Y VPWR VGND sg13g2_a21oi_1
X_5386_ _5386_/Y _5384_/Y _5385_/Y _8563_/B VPWR VGND sg13g2_a21oi_1
Xoutput2675 master_addr_o[22] _9880_/X VPWR VGND sg13g2_buf_1
Xoutput2686 master_addr_o[3] _9861_/X VPWR VGND sg13g2_buf_1
Xoutput2697 master_req_o _5040_/Y VPWR VGND sg13g2_buf_1
X_7125_ _8861_/D _7124_/Y _8861_/Q _7131_/S VPWR VGND sg13g2_mux2_1
XFILLER_99_584 VPWR VGND sg13g2_decap_8
XFILLER_86_223 VPWR VGND sg13g2_fill_2
XFILLER_59_426 VPWR VGND sg13g2_fill_2
X_4337_ _4337_/Y _8665_/Q VPWR VGND sg13g2_inv_1
XFILLER_115_58 VPWR VGND sg13g2_decap_4
XFILLER_101_567 VPWR VGND sg13g2_fill_1
XFILLER_101_545 VPWR VGND sg13g2_decap_8
X_7056_ _7056_/Y _7056_/A _8839_/Q VPWR VGND sg13g2_nand2_1
XFILLER_75_29 VPWR VGND sg13g2_fill_1
XFILLER_67_470 VPWR VGND sg13g2_decap_8
X_6007_ _9338_/D _9338_/Q _6037_/A _8820_/D VPWR VGND sg13g2_mux2_1
XFILLER_46_109 VPWR VGND sg13g2_decap_8
XFILLER_82_495 VPWR VGND sg13g2_decap_8
XFILLER_70_624 VPWR VGND sg13g2_fill_1
X_7958_ _8989_/D _5374_/C _7956_/A _7956_/Y VPWR VGND sg13g2_o21ai_1
X_6909_ _6909_/X _8895_/Q _8927_/Q _6909_/S VPWR VGND sg13g2_mux2_1
X_7889_ _7889_/Y _8039_/A _8039_/B _8039_/C _7889_/D VPWR VGND sg13g2_nand4_1
XFILLER_23_540 VPWR VGND sg13g2_fill_2
X_9628_ _9628_/Q _9701_/CLK _9628_/D fanout954/X VPWR VGND sg13g2_dfrbpq_1
XFILLER_50_392 VPWR VGND sg13g2_decap_8
X_9559_ _9559_/Q _9587_/CLK _9559_/D _9559_/RESET_B VPWR VGND sg13g2_dfrbpq_1
XFILLER_109_634 VPWR VGND sg13g2_fill_2
XFILLER_123_147 VPWR VGND sg13g2_decap_8
XFILLER_77_201 VPWR VGND sg13g2_decap_8
XFILLER_2_477 VPWR VGND sg13g2_decap_4
XFILLER_77_234 VPWR VGND sg13g2_decap_8
XFILLER_65_418 VPWR VGND sg13g2_fill_1
Xfanout770 _7187_/D slave_be_i[2] VPWR VGND sg13g2_buf_1
XFILLER_46_610 VPWR VGND sg13g2_decap_4
XFILLER_92_248 VPWR VGND sg13g2_decap_8
XFILLER_46_621 VPWR VGND sg13g2_fill_2
XFILLER_65_62 VPWR VGND sg13g2_fill_1
XFILLER_45_131 VPWR VGND sg13g2_fill_2
XFILLER_60_112 VPWR VGND sg13g2_decap_8
XFILLER_46_698 VPWR VGND sg13g2_fill_2
XFILLER_33_359 VPWR VGND sg13g2_fill_2
Xplace1917 _5360_/A _7028_/C VPWR VGND sg13g2_buf_1
XFILLER_6_750 VPWR VGND sg13g2_decap_8
Xplace1906 _6379_/A1 _6055_/A VPWR VGND sg13g2_buf_1
Xplace1939 _7794_/B1 _6972_/Y VPWR VGND sg13g2_buf_1
X_5240_ _5242_/B _9873_/A _5243_/B _5260_/C VPWR VGND sg13g2_nand3_1
XFILLER_6_783 VPWR VGND sg13g2_decap_8
Xplace1928 _6470_/A2 _6328_/A VPWR VGND sg13g2_buf_1
X_5171_ _8039_/D _8444_/C _9478_/Q VPWR VGND sg13g2_and2_1
XFILLER_83_215 VPWR VGND sg13g2_fill_1
X_8930_ _8930_/Q _9620_/CLK _8930_/D place2438/X VPWR VGND sg13g2_dfrbpq_1
XFILLER_37_610 VPWR VGND sg13g2_decap_4
XFILLER_84_749 VPWR VGND sg13g2_decap_4
XFILLER_92_760 VPWR VGND sg13g2_decap_8
XFILLER_64_451 VPWR VGND sg13g2_decap_8
X_8861_ _8861_/Q _9407_/CLK _8861_/D place2454/X VPWR VGND sg13g2_dfrbpq_1
XFILLER_37_676 VPWR VGND sg13g2_fill_2
X_7812_ _8924_/D _8924_/Q _7811_/Y _7812_/S VPWR VGND sg13g2_mux2_1
X_8792_ _8792_/Q _9254_/CLK _8792_/D place2423/X VPWR VGND sg13g2_dfrbpq_1
XFILLER_36_175 VPWR VGND sg13g2_decap_4
XFILLER_101_27 VPWR VGND sg13g2_fill_1
X_7743_ _7744_/D _9046_/Q _7719_/B _7741_/Y VPWR VGND sg13g2_o21ai_1
XFILLER_52_657 VPWR VGND sg13g2_decap_4
XFILLER_51_123 VPWR VGND sg13g2_fill_1
X_4955_ _4955_/X _4766_/A _4954_/Y _4750_/A VPWR VGND sg13g2_a21o_1
X_7674_ _7676_/C _8751_/Q _8515_/D VPWR VGND sg13g2_nand2_1
XFILLER_20_510 VPWR VGND sg13g2_decap_8
X_4886_ _4887_/B _4750_/A _4750_/B _4885_/Y VPWR VGND sg13g2_a21oi_1
X_6625_ _6625_/Y _9439_/Q _6651_/B VPWR VGND sg13g2_nand2_1
X_9413_ _9413_/Q _9414_/CLK _9413_/D place2500/X VPWR VGND sg13g2_dfrbpq_1
X_9344_ _9344_/Q _9414_/CLK _9344_/D place2502/X VPWR VGND sg13g2_dfrbpq_1
X_6556_ _6556_/X _6558_/A _9420_/Q _6737_/A _6558_/D VPWR VGND sg13g2_and4_1
X_9275_ _9275_/Q _9305_/CLK _9275_/D place2404/X VPWR VGND sg13g2_dfrbpq_1
X_5507_ _5507_/Y _5525_/A _5525_/B _8625_/Q _5525_/D VPWR VGND sg13g2_nand4_1
XFILLER_105_103 VPWR VGND sg13g2_fill_2
X_6487_ _6487_/Y _6485_/Y _6486_/Y _6455_/A VPWR VGND sg13g2_a21oi_1
XFILLER_10_35 VPWR VGND sg13g2_decap_8
X_8226_ _9113_/D _8226_/A1 _7957_/Y _8225_/Y VPWR VGND sg13g2_o21ai_1
XFILLER_121_618 VPWR VGND sg13g2_fill_1
XFILLER_105_136 VPWR VGND sg13g2_fill_1
X_5438_ _8677_/D _5438_/A _5438_/B_N VPWR VGND sg13g2_nor2b_1
X_5369_ _8809_/D _7024_/C _5836_/C _5369_/C _5372_/D VPWR VGND sg13g2_nor4_1
XFILLER_87_510 VPWR VGND sg13g2_fill_1
X_8157_ _8157_/Y _8157_/A _8157_/B VPWR VGND sg13g2_nand2_1
XFILLER_87_554 VPWR VGND sg13g2_fill_2
XFILLER_87_543 VPWR VGND sg13g2_decap_8
XFILLER_86_39 VPWR VGND sg13g2_fill_1
X_8088_ _8088_/Y _8088_/A _8101_/B VPWR VGND sg13g2_nand2_1
X_7108_ _7108_/Y _7210_/B _7210_/D _7123_/C VPWR VGND sg13g2_nand3_1
XFILLER_75_738 VPWR VGND sg13g2_decap_8
X_7039_ _8833_/D _7050_/A _7037_/Y _7038_/Y VPWR VGND sg13g2_o21ai_1
XFILLER_101_386 VPWR VGND sg13g2_decap_8
XFILLER_68_790 VPWR VGND sg13g2_fill_2
XFILLER_90_708 VPWR VGND sg13g2_fill_1
XFILLER_55_451 VPWR VGND sg13g2_decap_4
XFILLER_16_805 VPWR VGND sg13g2_decap_4
XFILLER_70_410 VPWR VGND sg13g2_decap_4
XFILLER_15_304 VPWR VGND sg13g2_decap_8
XFILLER_27_164 VPWR VGND sg13g2_decap_8
XFILLER_42_101 VPWR VGND sg13g2_fill_2
XFILLER_70_443 VPWR VGND sg13g2_fill_1
XFILLER_70_432 VPWR VGND sg13g2_decap_8
XFILLER_35_76 VPWR VGND sg13g2_decap_4
XFILLER_42_145 VPWR VGND sg13g2_decap_4
XFILLER_43_657 VPWR VGND sg13g2_decap_8
XFILLER_43_679 VPWR VGND sg13g2_fill_1
XFILLER_11_510 VPWR VGND sg13g2_fill_1
XFILLER_23_370 VPWR VGND sg13g2_fill_1
XFILLER_7_503 VPWR VGND sg13g2_fill_1
XFILLER_51_75 VPWR VGND sg13g2_decap_4
XFILLER_11_587 VPWR VGND sg13g2_decap_8
XFILLER_3_742 VPWR VGND sg13g2_fill_1
XFILLER_2_296 VPWR VGND sg13g2_fill_1
XFILLER_120_684 VPWR VGND sg13g2_decap_8
XFILLER_78_565 VPWR VGND sg13g2_fill_1
XFILLER_93_524 VPWR VGND sg13g2_fill_1
XFILLER_19_665 VPWR VGND sg13g2_fill_2
XFILLER_73_270 VPWR VGND sg13g2_decap_8
XFILLER_34_613 VPWR VGND sg13g2_decap_4
X_4740_ _4740_/Y _6071_/A _9691_/Q VPWR VGND sg13g2_nand2b_1
XFILLER_21_329 VPWR VGND sg13g2_decap_4
X_4671_ _4674_/B _9455_/Q _8743_/Q _9456_/Q VPWR VGND sg13g2_nor3_1
Xplace2404 place2404/X place2408/X VPWR VGND sg13g2_buf_1
X_6410_ _6410_/Y _6410_/A _6410_/B _6410_/C _6410_/D VPWR VGND sg13g2_nor4_1
X_7390_ _7390_/Y _7384_/Y _7389_/Y _7571_/B1 VPWR VGND sg13g2_o21ai_1
Xplace2415 place2415/X place2420/X VPWR VGND sg13g2_buf_1
Xplace2426 place2426/X place2453/X VPWR VGND sg13g2_buf_1
Xplace2437 place2437/X place2439/X VPWR VGND sg13g2_buf_1
X_6341_ _6342_/C _8864_/Q _6346_/B _6958_/C VPWR VGND sg13g2_nand3_1
Xplace2448 place2448/X place2449/X VPWR VGND sg13g2_buf_1
Xplace2459 place2459/X place2460/X VPWR VGND sg13g2_buf_1
Xhold3106 _8237_/A _9119_/Q VPWR VGND sg13g2_dlygate4sd3_1
Xplace1769 _7050_/A _7056_/A VPWR VGND sg13g2_buf_1
X_6272_ _6273_/C _6397_/B _6270_/Y _6271_/Y VPWR VGND sg13g2_o21ai_1
X_9060_ _9060_/Q _9183_/CLK _9060_/D place2472/X VPWR VGND sg13g2_dfrbpq_1
XFILLER_44_0 VPWR VGND sg13g2_decap_8
XFILLER_102_106 VPWR VGND sg13g2_decap_8
X_8011_ _8011_/Y _8011_/A _9016_/Q _8403_/C VPWR VGND sg13g2_nand3_1
XFILLER_69_510 VPWR VGND sg13g2_fill_2
X_5223_ _5224_/B _5272_/A _5223_/B _5238_/A _9871_/A VPWR VGND sg13g2_nand4_1
Xhold3117 _8024_/A _9022_/Q VPWR VGND sg13g2_dlygate4sd3_1
Xhold3139 _8044_/A _9030_/Q VPWR VGND sg13g2_dlygate4sd3_1
Xhold3128 _8239_/A _9120_/Q VPWR VGND sg13g2_dlygate4sd3_1
X_5154_ _7902_/D _5203_/A _9477_/Q VPWR VGND sg13g2_and2_1
XFILLER_29_418 VPWR VGND sg13g2_decap_4
X_5085_ _5085_/Y _9261_/Q _9259_/Q _5085_/C _5085_/D VPWR VGND sg13g2_nor4_1
X_8913_ _8913_/Q _9611_/CLK _8913_/D place2412/X VPWR VGND sg13g2_dfrbpq_1
XFILLER_65_771 VPWR VGND sg13g2_fill_1
X_8844_ _8844_/Q _9242_/CLK _8844_/D place2492/X VPWR VGND sg13g2_dfrbpq_1
XFILLER_24_112 VPWR VGND sg13g2_decap_8
X_5987_ _5987_/Y _8528_/C _5297_/Y _5986_/Y VPWR VGND sg13g2_o21ai_1
X_8775_ _9881_/A _9260_/CLK _8775_/D place2392/X VPWR VGND sg13g2_dfrbpq_1
XFILLER_24_167 VPWR VGND sg13g2_decap_4
X_9602__2788 _9602_/RESET_B VPWR VGND sg13g2_tiehi
X_7726_ _7727_/D _9107_/Q _4497_/Y _7667_/A VPWR VGND sg13g2_o21ai_1
X_4938_ _4938_/Y _4844_/B _4791_/B _4937_/C VPWR VGND sg13g2_a21oi_1
X_7657_ _7657_/Y _7829_/A _7656_/Y VPWR VGND sg13g2_nor2b_1
X_4869_ _4869_/Y _4844_/B _4766_/A _4832_/Y VPWR VGND sg13g2_a21oi_1
XFILLER_122_7 VPWR VGND sg13g2_decap_8
X_6608_ _6608_/Y _8636_/Q _6666_/A2 _6607_/X VPWR VGND sg13g2_o21ai_1
XFILLER_119_773 VPWR VGND sg13g2_decap_8
X_7588_ _7591_/C _7759_/A _9007_/Q _7802_/C VPWR VGND sg13g2_nor3_1
XFILLER_20_395 VPWR VGND sg13g2_decap_4
X_9327_ _9327_/Q _9410_/CLK _9327_/D place2397/X VPWR VGND sg13g2_dfrbpq_1
X_6539_ _9414_/D _9414_/Q _6539_/A1 _6539_/S VPWR VGND sg13g2_mux2_1
XFILLER_97_27 VPWR VGND sg13g2_fill_2
X_9258_ _9258_/Q _9675_/CLK _9258_/D place2444/X VPWR VGND sg13g2_dfrbpq_1
XFILLER_121_404 VPWR VGND sg13g2_fill_1
X_8209_ _8209_/Y _8209_/A _8221_/B VPWR VGND sg13g2_nand2_1
X_9189_ _9189_/Q _9251_/CLK _9189_/D place2461/X VPWR VGND sg13g2_dfrbpq_1
XFILLER_102_651 VPWR VGND sg13g2_decap_8
XFILLER_75_502 VPWR VGND sg13g2_decap_4
XFILLER_48_727 VPWR VGND sg13g2_fill_2
XFILLER_0_778 VPWR VGND sg13g2_fill_1
Xhold2950 _5630_/B1 _8618_/Q VPWR VGND sg13g2_dlygate4sd3_1
XFILLER_47_204 VPWR VGND sg13g2_decap_4
XFILLER_102_695 VPWR VGND sg13g2_decap_8
Xhold2961 _7859_/B1 _8936_/Q VPWR VGND sg13g2_dlygate4sd3_1
XFILLER_87_395 VPWR VGND sg13g2_fill_2
Xhold2972 _6419_/B1 _9391_/Q VPWR VGND sg13g2_dlygate4sd3_1
Xhold2983 _6075_/B1 _9346_/Q VPWR VGND sg13g2_dlygate4sd3_1
XFILLER_47_237 VPWR VGND sg13g2_decap_8
Xhold2994 _6621_/A _9438_/Q VPWR VGND sg13g2_dlygate4sd3_1
XFILLER_46_31 VPWR VGND sg13g2_fill_2
XFILLER_90_516 VPWR VGND sg13g2_fill_2
XFILLER_71_752 VPWR VGND sg13g2_decap_8
XFILLER_71_763 VPWR VGND sg13g2_fill_1
XFILLER_70_240 VPWR VGND sg13g2_decap_8
XFILLER_31_605 VPWR VGND sg13g2_decap_8
XFILLER_7_14 VPWR VGND sg13g2_decap_8
XFILLER_116_209 VPWR VGND sg13g2_decap_8
XFILLER_7_377 VPWR VGND sg13g2_decap_4
XFILLER_109_294 VPWR VGND sg13g2_fill_1
XFILLER_3_561 VPWR VGND sg13g2_fill_2
XFILLER_97_148 VPWR VGND sg13g2_fill_2
XFILLER_97_137 VPWR VGND sg13g2_decap_4
XFILLER_87_82 VPWR VGND sg13g2_fill_2
XFILLER_78_351 VPWR VGND sg13g2_decap_8
XFILLER_38_226 VPWR VGND sg13g2_decap_8
XFILLER_93_365 VPWR VGND sg13g2_decap_8
X_5910_ _5910_/Y _5934_/A1 _9480_/Q _5909_/Y VPWR VGND sg13g2_o21ai_1
XFILLER_93_387 VPWR VGND sg13g2_decap_8
XFILLER_53_207 VPWR VGND sg13g2_fill_2
XFILLER_47_782 VPWR VGND sg13g2_fill_1
XFILLER_19_462 VPWR VGND sg13g2_decap_4
X_6890_ _9611_/D _6889_/X _9611_/Q _6910_/S VPWR VGND sg13g2_mux2_1
XFILLER_62_752 VPWR VGND sg13g2_decap_4
XFILLER_34_432 VPWR VGND sg13g2_decap_8
X_5841_ _5841_/X _5986_/A _5907_/A1 _5945_/A VPWR VGND sg13g2_mux2_1
X_5772_ _5772_/Y _5772_/A1 _5770_/Y _5771_/Y VPWR VGND sg13g2_a21oi_1
X_8560_ _8561_/A _9273_/Q _8560_/A2 _8560_/B1 _9499_/Q VPWR VGND sg13g2_a22oi_1
XFILLER_21_115 VPWR VGND sg13g2_decap_4
XFILLER_21_126 VPWR VGND sg13g2_fill_1
X_4723_ _9687_/D _4723_/A _4729_/A VPWR VGND sg13g2_nor2_1
X_8491_ _9250_/D _8490_/A _5365_/C _8490_/Y VPWR VGND sg13g2_o21ai_1
X_7511_ _7511_/Y _7822_/A _7511_/B _7511_/C _7511_/D VPWR VGND sg13g2_nor4_1
X_7442_ _7442_/Y _7442_/A _7442_/B VPWR VGND sg13g2_nand2_1
X_4654_ _4660_/A _9644_/Q _8717_/Q _9647_/Q VPWR VGND sg13g2_a21oi_1
Xplace2212 _5525_/B _6541_/A VPWR VGND sg13g2_buf_1
Xplace2201 _5472_/B_N _6737_/C VPWR VGND sg13g2_buf_1
XFILLER_30_693 VPWR VGND sg13g2_decap_8
Xplace2234 _7704_/A _7431_/A VPWR VGND sg13g2_buf_1
X_7373_ _7376_/B _7373_/A _8498_/B _7730_/C VPWR VGND sg13g2_nand3_1
Xplace2245 _7803_/A _7783_/C VPWR VGND sg13g2_buf_1
Xplace2223 _7389_/A _7407_/A VPWR VGND sg13g2_buf_1
X_4585_ _6939_/C _9698_/Q _9706_/Q VPWR VGND sg13g2_nor2_1
XFILLER_116_743 VPWR VGND sg13g2_decap_8
Xplace2278 _5826_/A _7644_/B VPWR VGND sg13g2_buf_1
Xplace2267 _7741_/B _7783_/B VPWR VGND sg13g2_buf_1
Xplace2256 _7278_/C _7296_/C VPWR VGND sg13g2_buf_1
X_6324_ _6324_/Y _6271_/A _6438_/D _6323_/Y _6332_/C _6273_/A VPWR VGND sg13g2_a221oi_1
X_9112_ _9112_/Q clkload8/A _9112_/D place2465/X VPWR VGND sg13g2_dfrbpq_1
Xplace2289 _4937_/C _4945_/A VPWR VGND sg13g2_buf_1
XFILLER_88_115 VPWR VGND sg13g2_fill_1
XFILLER_88_104 VPWR VGND sg13g2_decap_8
X_9043_ _9043_/Q _9198_/CLK _9043_/D place2439/X VPWR VGND sg13g2_dfrbpq_1
X_6255_ _6265_/A _6275_/B _6254_/Y _6319_/C1 VPWR VGND sg13g2_a21oi_1
X_5206_ _5207_/B _5215_/A _9868_/A _9867_/A _9866_/A VPWR VGND sg13g2_nand4_1
X_6186_ _6186_/Y _8845_/Q _6130_/B _6178_/Y _6181_/Y _6184_/Y VPWR VGND sg13g2_a221oi_1
XFILLER_123_14 VPWR VGND sg13g2_decap_8
XFILLER_97_682 VPWR VGND sg13g2_decap_4
X_5137_ _5139_/B _5119_/B _5120_/A _5136_/Y VPWR VGND sg13g2_a21oi_1
XFILLER_96_192 VPWR VGND sg13g2_decap_8
X_5068_ _5382_/C _7245_/D _9467_/Q _7245_/B _7245_/A VPWR VGND sg13g2_nand4_1
XFILLER_38_760 VPWR VGND sg13g2_decap_8
X_9876_ _9876_/X _9876_/A VPWR VGND sg13g2_buf_1
XFILLER_72_549 VPWR VGND sg13g2_decap_4
XFILLER_53_730 VPWR VGND sg13g2_fill_2
XFILLER_37_292 VPWR VGND sg13g2_decap_4
X_8827_ _8827_/Q _9620_/CLK _8827_/D place2430/X VPWR VGND sg13g2_dfrbpq_1
XFILLER_40_402 VPWR VGND sg13g2_fill_2
X_8758_ _9864_/A _9219_/CLK _8758_/D place2408/X VPWR VGND sg13g2_dfrbpq_1
X_7709_ _7709_/Y _7709_/A _7709_/B _7709_/C _7709_/D VPWR VGND sg13g2_nor4_1
XFILLER_8_108 VPWR VGND sg13g2_decap_8
X_8689_ _8689_/Q _9630_/CLK _8689_/D fanout946/X VPWR VGND sg13g2_dfrbpq_1
XFILLER_21_660 VPWR VGND sg13g2_decap_4
XFILLER_21_682 VPWR VGND sg13g2_fill_2
XFILLER_20_192 VPWR VGND sg13g2_decap_8
XFILLER_32_88 VPWR VGND sg13g2_decap_4
XFILLER_107_765 VPWR VGND sg13g2_decap_8
XFILLER_107_787 VPWR VGND sg13g2_fill_2
XFILLER_79_148 VPWR VGND sg13g2_fill_1
XFILLER_95_619 VPWR VGND sg13g2_decap_8
XFILLER_88_682 VPWR VGND sg13g2_decap_8
XFILLER_87_170 VPWR VGND sg13g2_decap_8
XFILLER_75_321 VPWR VGND sg13g2_decap_8
XFILLER_48_535 VPWR VGND sg13g2_decap_8
XFILLER_48_513 VPWR VGND sg13g2_decap_4
XFILLER_48_568 VPWR VGND sg13g2_fill_2
XFILLER_63_538 VPWR VGND sg13g2_decap_8
XFILLER_29_760 VPWR VGND sg13g2_fill_2
XFILLER_90_324 VPWR VGND sg13g2_decap_8
XFILLER_29_793 VPWR VGND sg13g2_fill_1
XFILLER_73_51 VPWR VGND sg13g2_decap_8
XFILLER_16_487 VPWR VGND sg13g2_fill_2
XFILLER_12_682 VPWR VGND sg13g2_decap_8
XFILLER_12_693 VPWR VGND sg13g2_fill_2
XFILLER_8_686 VPWR VGND sg13g2_decap_8
X_4370_ _4481_/A _9658_/Q _9209_/Q _4480_/B VPWR VGND sg13g2_nor3_1
XFILLER_86_608 VPWR VGND sg13g2_fill_1
X_6040_ _6410_/C _6041_/B _6365_/C _6365_/B _6049_/A VPWR VGND sg13g2_nand4_1
XFILLER_121_790 VPWR VGND sg13g2_fill_2
XFILLER_79_682 VPWR VGND sg13g2_fill_1
XFILLER_78_170 VPWR VGND sg13g2_fill_1
XFILLER_94_696 VPWR VGND sg13g2_fill_1
XFILLER_94_685 VPWR VGND sg13g2_decap_8
XFILLER_66_376 VPWR VGND sg13g2_decap_8
X_7991_ _7991_/Y _8019_/A _9006_/Q _8383_/C VPWR VGND sg13g2_nand3_1
XFILLER_39_579 VPWR VGND sg13g2_fill_1
XFILLER_81_324 VPWR VGND sg13g2_decap_8
XFILLER_66_398 VPWR VGND sg13g2_fill_2
X_6942_ _6943_/A _6561_/B _6941_/Y _6951_/A _6737_/B VPWR VGND sg13g2_a22oi_1
XFILLER_19_281 VPWR VGND sg13g2_decap_8
X_9661_ _9661_/Q _9662_/CLK _9661_/D place2448/X VPWR VGND sg13g2_dfrbpq_1
X_6873_ _6873_/X _8910_/Q _8942_/Q _6877_/S VPWR VGND sg13g2_mux2_1
X_5824_ _5825_/A _9305_/Q _5786_/Y _5787_/Y _9502_/Q VPWR VGND sg13g2_a22oi_1
XFILLER_22_413 VPWR VGND sg13g2_fill_2
X_8612_ _8612_/Q _9701_/CLK _8612_/D fanout950/X VPWR VGND sg13g2_dfrbpq_1
X_9592_ _9592_/Q _9672_/CLK _9592_/D _9592_/RESET_B VPWR VGND sg13g2_dfrbpq_1
X_9511__2869 _9511_/RESET_B VPWR VGND sg13g2_tiehi
X_5755_ _5755_/Y _5771_/A1 _9309_/Q _5772_/A1 VPWR VGND sg13g2_a21oi_1
X_8543_ _8543_/X _8532_/B _8532_/C _8526_/Y VPWR VGND sg13g2_a21o_1
XFILLER_10_619 VPWR VGND sg13g2_decap_4
X_4706_ _4707_/B _9669_/Q _8740_/Q VPWR VGND sg13g2_nor2b_1
X_5686_ _8596_/D _5686_/A VPWR VGND sg13g2_inv_1
X_8474_ _8474_/Y _8474_/A _8474_/B _8474_/C VPWR VGND sg13g2_nand3_1
XFILLER_118_14 VPWR VGND sg13g2_decap_8
Xplace2020 _6836_/S _6840_/S VPWR VGND sg13g2_buf_1
X_4637_ _4640_/D _9210_/Q _9644_/Q _9647_/Q _9646_/Q VPWR VGND sg13g2_nor4_1
X_7425_ _7425_/Y _9061_/Q _7492_/B _7425_/C VPWR VGND sg13g2_nand3b_1
Xplace2053 _5580_/B1 _5586_/B1 VPWR VGND sg13g2_buf_1
Xplace2042 _5836_/D _5828_/D VPWR VGND sg13g2_buf_1
Xplace2031 _6271_/A _6079_/A VPWR VGND sg13g2_buf_1
Xplace2064 _8314_/A1 _7028_/D VPWR VGND sg13g2_buf_1
XFILLER_116_573 VPWR VGND sg13g2_decap_8
X_7356_ _7358_/A _9279_/Q _7557_/A2 _7557_/B1 _9311_/Q VPWR VGND sg13g2_a22oi_1
Xplace2086 _5771_/A1 _5739_/A VPWR VGND sg13g2_buf_1
X_4568_ _4568_/Y _9667_/Q _4568_/B VPWR VGND sg13g2_nor2_1
Xplace2097 _4939_/A2 _4750_/A VPWR VGND sg13g2_buf_1
Xplace2075 _6994_/D _5343_/Y VPWR VGND sg13g2_buf_1
XFILLER_89_435 VPWR VGND sg13g2_decap_8
X_7287_ _7287_/Y _9212_/Q _7695_/A2 _7737_/B1 _7287_/B2 _7286_/Y VPWR VGND sg13g2_a221oi_1
X_4499_ _4523_/B _7269_/A _8498_/C VPWR VGND sg13g2_and2_1
X_6307_ _6307_/Y _6248_/C _6306_/Y _6299_/Y VPWR VGND sg13g2_a21oi_1
XFILLER_103_267 VPWR VGND sg13g2_decap_8
X_9026_ _9026_/Q clkload5/A _9026_/D place2484/X VPWR VGND sg13g2_dfrbpq_1
X_6238_ _6238_/Y _6238_/A _6238_/B _6238_/C _6369_/A VPWR VGND sg13g2_nand4_1
X_6169_ _6169_/Y _8844_/Q _6462_/A2 _6168_/X _6401_/B2 VPWR VGND sg13g2_a22oi_1
XFILLER_85_652 VPWR VGND sg13g2_fill_1
XFILLER_84_151 VPWR VGND sg13g2_fill_2
XFILLER_57_387 VPWR VGND sg13g2_decap_8
XFILLER_27_22 VPWR VGND sg13g2_fill_1
XFILLER_26_730 VPWR VGND sg13g2_decap_8
X_9859_ _9859_/X _9859_/A VPWR VGND sg13g2_buf_1
XFILLER_72_368 VPWR VGND sg13g2_fill_1
XFILLER_111_0 VPWR VGND sg13g2_fill_2
XFILLER_5_645 VPWR VGND sg13g2_fill_2
XFILLER_5_689 VPWR VGND sg13g2_decap_4
XFILLER_4_144 VPWR VGND sg13g2_decap_8
XFILLER_122_554 VPWR VGND sg13g2_fill_1
XFILLER_108_91 VPWR VGND sg13g2_decap_8
XFILLER_110_749 VPWR VGND sg13g2_fill_2
XFILLER_67_129 VPWR VGND sg13g2_decap_8
XFILLER_76_641 VPWR VGND sg13g2_decap_8
X_9561__2829 _9561_/RESET_B VPWR VGND sg13g2_tiehi
XFILLER_0_394 VPWR VGND sg13g2_decap_4
XFILLER_91_611 VPWR VGND sg13g2_decap_8
XFILLER_91_600 VPWR VGND sg13g2_fill_2
XFILLER_76_685 VPWR VGND sg13g2_decap_8
XFILLER_91_688 VPWR VGND sg13g2_decap_4
XFILLER_32_722 VPWR VGND sg13g2_decap_8
XFILLER_32_777 VPWR VGND sg13g2_fill_1
X_5540_ _5540_/Y _5597_/A _5597_/B _8636_/Q _5597_/D VPWR VGND sg13g2_nand4_1
X_5471_ _5472_/A _4387_/Y _8694_/Q _8695_/Q _4388_/X VPWR VGND sg13g2_a22oi_1
XFILLER_117_337 VPWR VGND sg13g2_decap_8
X_7210_ _7210_/Y _7236_/A _7210_/B _8496_/B _7210_/D VPWR VGND sg13g2_nand4_1
X_4422_ _6090_/A _6509_/D _6262_/C _4422_/C VPWR VGND sg13g2_nand3_1
X_8190_ _9095_/D _8190_/A1 _8053_/Y _8189_/Y VPWR VGND sg13g2_o21ai_1
X_4353_ _8743_/D _7002_/B _4506_/B _4506_/C VPWR VGND sg13g2_nand3_1
X_7141_ _7141_/Y _7156_/A _8866_/Q VPWR VGND sg13g2_nand2_1
XFILLER_101_705 VPWR VGND sg13g2_decap_8
X_7072_ _7072_/Y _5355_/C _6967_/Y _7071_/Y VPWR VGND sg13g2_o21ai_1
XFILLER_101_749 VPWR VGND sg13g2_decap_4
XFILLER_58_118 VPWR VGND sg13g2_decap_4
X_6023_ _6024_/A _6046_/A _6071_/B _8817_/D VPWR VGND sg13g2_nand3_1
XFILLER_100_259 VPWR VGND sg13g2_decap_8
XFILLER_67_630 VPWR VGND sg13g2_decap_8
Xclkbuf_leaf_14_clk_i _9305_/CLK clkbuf_3_6__f_clk_i/X VPWR VGND sg13g2_buf_16
XFILLER_54_346 VPWR VGND sg13g2_fill_2
X_7974_ _8997_/D _5351_/C _7975_/A _7973_/Y VPWR VGND sg13g2_o21ai_1
XFILLER_82_677 VPWR VGND sg13g2_decap_8
X_6925_ _9627_/D _9627_/Q _6915_/B _6924_/X VPWR VGND sg13g2_a21o_1
X_9644_ _9644_/Q _9649_/CLK _9644_/D fanout973/X VPWR VGND sg13g2_dfrbpq_1
X_6856_ _9594_/D _6855_/X _9594_/Q _6906_/S VPWR VGND sg13g2_mux2_1
XFILLER_23_755 VPWR VGND sg13g2_decap_8
XFILLER_23_766 VPWR VGND sg13g2_fill_1
X_9575_ _9575_/Q _9582_/CLK _9575_/D _9575_/RESET_B VPWR VGND sg13g2_dfrbpq_1
X_5807_ _9296_/D _5807_/A VPWR VGND sg13g2_inv_1
X_6787_ _6787_/Y _9546_/Q _6785_/S _4634_/A VPWR VGND sg13g2_o21ai_1
Xclkbuf_leaf_29_clk_i _9251_/CLK clkbuf_3_2__f_clk_i/X VPWR VGND sg13g2_buf_16
X_8526_ _8526_/Y _5132_/D _8532_/B _8540_/A VPWR VGND sg13g2_o21ai_1
X_5738_ _5738_/Y _5890_/A _5890_/B _9313_/Q _5890_/D VPWR VGND sg13g2_nand4_1
XFILLER_89_28 VPWR VGND sg13g2_decap_8
X_8457_ _9233_/D _8474_/A _5347_/C _8456_/Y VPWR VGND sg13g2_o21ai_1
X_5669_ _5670_/A _8604_/Q _5624_/X _5629_/Y _8605_/Q VPWR VGND sg13g2_a22oi_1
X_8388_ _9194_/D _5362_/C _8401_/A _8387_/Y VPWR VGND sg13g2_o21ai_1
X_7408_ _7412_/C _9184_/Q _7381_/B _7407_/A VPWR VGND sg13g2_o21ai_1
XFILLER_89_210 VPWR VGND sg13g2_fill_2
X_7339_ _7340_/B _8788_/Q _7824_/B _7640_/A2 _9862_/A VPWR VGND sg13g2_a22oi_1
XFILLER_89_243 VPWR VGND sg13g2_fill_2
Xfanout941 _8530_/D _5934_/A1 VPWR VGND sg13g2_buf_1
X_9009_ _9009_/Q _9304_/CLK _9009_/D place2410/X VPWR VGND sg13g2_dfrbpq_1
Xfanout952 fanout952/X fanout956/X VPWR VGND sg13g2_buf_1
Xfanout974 fanout974/X fanout975/X VPWR VGND sg13g2_buf_1
XFILLER_58_652 VPWR VGND sg13g2_decap_8
XFILLER_58_630 VPWR VGND sg13g2_decap_8
Xfanout963 fanout963/X fanout964/X VPWR VGND sg13g2_buf_1
Xfanout985 fanout985/X input2574/X VPWR VGND sg13g2_buf_1
XFILLER_38_54 VPWR VGND sg13g2_fill_1
XFILLER_92_419 VPWR VGND sg13g2_decap_4
XFILLER_85_460 VPWR VGND sg13g2_fill_2
XFILLER_18_505 VPWR VGND sg13g2_decap_4
XFILLER_73_633 VPWR VGND sg13g2_fill_2
XFILLER_38_98 VPWR VGND sg13g2_decap_8
XFILLER_33_508 VPWR VGND sg13g2_fill_1
XFILLER_45_357 VPWR VGND sg13g2_decap_8
XFILLER_72_198 VPWR VGND sg13g2_fill_1
XFILLER_54_64 VPWR VGND sg13g2_decap_8
XFILLER_54_53 VPWR VGND sg13g2_fill_2
XFILLER_53_390 VPWR VGND sg13g2_decap_8
XFILLER_41_552 VPWR VGND sg13g2_fill_2
XFILLER_9_214 VPWR VGND sg13g2_fill_2
Xclkload17 clkload17/Y _9620_/CLK VPWR VGND sg13g2_inv_1
XFILLER_5_420 VPWR VGND sg13g2_decap_4
Xclkload28 clkload28/Y _9511_/CLK VPWR VGND sg13g2_inv_16
X_9615__2775 _9615_/RESET_B VPWR VGND sg13g2_tiehi
XFILLER_48_7 VPWR VGND sg13g2_fill_1
XFILLER_96_736 VPWR VGND sg13g2_decap_8
XFILLER_49_641 VPWR VGND sg13g2_decap_4
XFILLER_95_279 VPWR VGND sg13g2_decap_4
XFILLER_95_71 VPWR VGND sg13g2_decap_8
XFILLER_64_622 VPWR VGND sg13g2_decap_8
XFILLER_91_441 VPWR VGND sg13g2_decap_8
X_4971_ _4974_/A _5006_/A1 _4971_/B VPWR VGND sg13g2_nand2b_1
XFILLER_17_571 VPWR VGND sg13g2_decap_8
X_7690_ _7692_/C _7690_/A _9136_/Q _7747_/C VPWR VGND sg13g2_nor3_1
X_6710_ _9478_/D _9519_/Q _9478_/Q _6710_/S VPWR VGND sg13g2_mux2_1
XFILLER_51_349 VPWR VGND sg13g2_fill_1
X_6641_ _6641_/Y _9444_/Q _6651_/B VPWR VGND sg13g2_nand2_1
XFILLER_20_758 VPWR VGND sg13g2_decap_8
X_9360_ _9360_/Q clkload9/A _9360_/D place2493/X VPWR VGND sg13g2_dfrbpq_1
X_6572_ _6572_/Y _6588_/C _8625_/Q _9557_/Q _6566_/Y VPWR VGND sg13g2_a22oi_1
X_8311_ _8311_/Y _8311_/A _8347_/B VPWR VGND sg13g2_nand2_1
X_9291_ _9291_/Q _9305_/CLK _9291_/D place2419/X VPWR VGND sg13g2_dfrbpq_1
X_5523_ _5523_/Y _9427_/Q _5615_/B _5523_/B1 _8629_/Q VPWR VGND sg13g2_a22oi_1
XFILLER_118_668 VPWR VGND sg13g2_fill_1
XFILLER_117_167 VPWR VGND sg13g2_decap_8
X_5454_ _8685_/D _5454_/A _5454_/B_N VPWR VGND sg13g2_nor2b_1
X_8242_ _9121_/D _8244_/A1 _8039_/Y _8241_/Y VPWR VGND sg13g2_o21ai_1
X_5385_ _5385_/Y _5387_/B _8520_/C _5376_/Y VPWR VGND sg13g2_a21oi_1
Xoutput2665 master_addr_o[13] _9871_/X VPWR VGND sg13g2_buf_1
X_8173_ _8173_/Y _8173_/A _8197_/B VPWR VGND sg13g2_nand2_1
X_4405_ _4405_/Y _4405_/A _5434_/B VPWR VGND sg13g2_nor2_1
X_4336_ _4480_/B _9656_/Q VPWR VGND sg13g2_inv_1
XFILLER_99_563 VPWR VGND sg13g2_decap_8
XFILLER_99_541 VPWR VGND sg13g2_fill_2
Xoutput2698 master_wdata_o[0] _5709_/X VPWR VGND sg13g2_buf_1
Xoutput2676 master_addr_o[23] _9881_/X VPWR VGND sg13g2_buf_1
Xoutput2687 master_addr_o[4] _9862_/X VPWR VGND sg13g2_buf_1
X_7124_ _7124_/Y _5372_/C _7127_/A2 _7123_/Y VPWR VGND sg13g2_o21ai_1
XFILLER_101_524 VPWR VGND sg13g2_decap_8
XFILLER_101_502 VPWR VGND sg13g2_fill_2
XFILLER_59_405 VPWR VGND sg13g2_decap_8
XFILLER_113_395 VPWR VGND sg13g2_decap_8
XFILLER_87_769 VPWR VGND sg13g2_fill_2
XFILLER_59_449 VPWR VGND sg13g2_fill_2
X_7055_ _7055_/Y _7902_/D _6966_/Y _7036_/X _4435_/D VPWR VGND sg13g2_a22oi_1
X_6006_ _9337_/D _6005_/Y _9337_/Q _6006_/S VPWR VGND sg13g2_mux2_1
XFILLER_27_324 VPWR VGND sg13g2_fill_2
XFILLER_39_184 VPWR VGND sg13g2_decap_8
XFILLER_70_603 VPWR VGND sg13g2_decap_8
XFILLER_15_508 VPWR VGND sg13g2_decap_4
XFILLER_55_688 VPWR VGND sg13g2_decap_8
XFILLER_42_305 VPWR VGND sg13g2_decap_8
X_7957_ _7957_/Y _8086_/A _9501_/Q _8056_/C _8086_/D VPWR VGND sg13g2_nand4_1
X_6908_ _9620_/D _6907_/X _9620_/Q _8503_/B VPWR VGND sg13g2_mux2_1
X_7888_ _7888_/Y _7899_/A _8960_/Q _8353_/C VPWR VGND sg13g2_nand3_1
XFILLER_42_338 VPWR VGND sg13g2_fill_2
X_6839_ _9587_/D _9620_/Q _9587_/Q _6839_/S VPWR VGND sg13g2_mux2_1
XFILLER_11_703 VPWR VGND sg13g2_fill_1
XFILLER_23_552 VPWR VGND sg13g2_fill_1
X_9627_ _9627_/Q _9701_/CLK _9627_/D fanout952/X VPWR VGND sg13g2_dfrbpq_1
X_9558_ _9558_/Q _9587_/CLK _9558_/D _9558_/RESET_B VPWR VGND sg13g2_dfrbpq_1
XFILLER_10_268 VPWR VGND sg13g2_fill_1
X_9489_ _9489_/Q _9621_/CLK _9489_/D _9489_/RESET_B VPWR VGND sg13g2_dfrbpq_1
XFILLER_108_134 VPWR VGND sg13g2_decap_8
XFILLER_108_112 VPWR VGND sg13g2_fill_2
X_8509_ _8509_/Y _9257_/Q _8509_/B VPWR VGND sg13g2_nand2_1
XFILLER_109_679 VPWR VGND sg13g2_decap_8
XFILLER_123_126 VPWR VGND sg13g2_decap_8
XFILLER_108_178 VPWR VGND sg13g2_decap_8
XFILLER_104_395 VPWR VGND sg13g2_decap_8
XFILLER_78_758 VPWR VGND sg13g2_decap_8
XFILLER_93_717 VPWR VGND sg13g2_fill_1
XFILLER_65_408 VPWR VGND sg13g2_decap_4
XFILLER_92_227 VPWR VGND sg13g2_decap_8
XFILLER_1_49 VPWR VGND sg13g2_decap_8
XFILLER_45_110 VPWR VGND sg13g2_decap_8
XFILLER_33_316 VPWR VGND sg13g2_decap_8
XFILLER_33_327 VPWR VGND sg13g2_fill_1
XFILLER_45_187 VPWR VGND sg13g2_fill_1
XFILLER_61_658 VPWR VGND sg13g2_decap_4
XFILLER_60_135 VPWR VGND sg13g2_fill_1
Xplace1918 _7028_/C _7024_/C VPWR VGND sg13g2_buf_1
Xplace1907 _7829_/A _5377_/X VPWR VGND sg13g2_buf_1
Xplace1929 _6328_/A _6379_/A2 VPWR VGND sg13g2_buf_1
XFILLER_96_511 VPWR VGND sg13g2_decap_8
X_5170_ _8758_/D _5080_/Y _5350_/C _5169_/Y _5075_/X VPWR VGND sg13g2_a22oi_1
XFILLER_69_714 VPWR VGND sg13g2_fill_2
XFILLER_122_170 VPWR VGND sg13g2_fill_2
XFILLER_96_533 VPWR VGND sg13g2_decap_8
XFILLER_84_706 VPWR VGND sg13g2_decap_8
XFILLER_68_257 VPWR VGND sg13g2_fill_1
XFILLER_56_408 VPWR VGND sg13g2_decap_8
X_8860_ _8860_/Q _9407_/CLK _8860_/D place2460/X VPWR VGND sg13g2_dfrbpq_1
XFILLER_25_806 VPWR VGND sg13g2_fill_2
X_7811_ _7811_/Y _7811_/A _7811_/B _7811_/C _7811_/D VPWR VGND sg13g2_nor4_1
X_8791_ _8791_/Q _9219_/CLK _8791_/D place2422/X VPWR VGND sg13g2_dfrbpq_1
XFILLER_64_485 VPWR VGND sg13g2_decap_8
XFILLER_52_603 VPWR VGND sg13g2_fill_1
X_7742_ _7744_/C _7747_/A _9015_/Q _7747_/C VPWR VGND sg13g2_nor3_1
XFILLER_24_338 VPWR VGND sg13g2_decap_8
X_4954_ _4954_/Y _4823_/B _4923_/A _4861_/Y VPWR VGND sg13g2_o21ai_1
XFILLER_60_680 VPWR VGND sg13g2_fill_2
X_9412_ _9412_/Q _9414_/CLK _9412_/D place2500/X VPWR VGND sg13g2_dfrbpq_1
X_4885_ _4885_/Y _4925_/A2 _4945_/C _4811_/Y VPWR VGND sg13g2_a21oi_1
X_7673_ _7676_/B _7667_/Y _7672_/Y _8056_/D VPWR VGND sg13g2_o21ai_1
X_6624_ _9438_/D _6656_/A1 _6623_/Y _6621_/Y VPWR VGND sg13g2_o21ai_1
XFILLER_20_566 VPWR VGND sg13g2_fill_1
XFILLER_20_577 VPWR VGND sg13g2_decap_8
X_9343_ _9343_/Q clkload9/A _9343_/D place2490/X VPWR VGND sg13g2_dfrbpq_1
X_6555_ _9419_/D _8660_/Q _6544_/Y _6554_/X VPWR VGND sg13g2_a21o_1
X_9274_ _9274_/Q _9305_/CLK _9274_/D place2405/X VPWR VGND sg13g2_dfrbpq_1
X_5506_ _8623_/D _5506_/A _5506_/B VPWR VGND sg13g2_nor2_1
XFILLER_118_487 VPWR VGND sg13g2_fill_1
X_6486_ _6486_/Y _9079_/Q _6506_/B1 _6507_/B1 _9141_/Q VPWR VGND sg13g2_a22oi_1
XFILLER_10_14 VPWR VGND sg13g2_decap_8
X_8225_ _8225_/Y _8225_/A _8225_/B VPWR VGND sg13g2_nand2_1
X_5437_ _5438_/A _5439_/A1 _8677_/Q _8678_/Q _5451_/B2 VPWR VGND sg13g2_a22oi_1
X_5368_ _8808_/D _7028_/C _5836_/C _5368_/C _5372_/D VPWR VGND sg13g2_nor4_1
X_8156_ _9078_/D _8156_/A1 _8092_/Y _8155_/Y VPWR VGND sg13g2_o21ai_1
XFILLER_86_29 VPWR VGND sg13g2_fill_1
X_5299_ _5314_/D _7729_/B _5306_/B VPWR VGND sg13g2_nor2_1
X_4319_ _5205_/A _9868_/A VPWR VGND sg13g2_inv_1
X_8087_ _9045_/D _8098_/A1 _8086_/Y _8085_/Y VPWR VGND sg13g2_o21ai_1
X_7107_ _8855_/D _7106_/Y _8855_/Q _7110_/S VPWR VGND sg13g2_mux2_1
XFILLER_87_566 VPWR VGND sg13g2_fill_1
XFILLER_75_717 VPWR VGND sg13g2_decap_8
X_7038_ _7038_/Y _7050_/A _8833_/Q VPWR VGND sg13g2_nand2_1
XFILLER_101_398 VPWR VGND sg13g2_decap_8
XFILLER_28_611 VPWR VGND sg13g2_decap_8
XFILLER_27_121 VPWR VGND sg13g2_decap_8
XFILLER_70_400 VPWR VGND sg13g2_fill_1
XFILLER_35_11 VPWR VGND sg13g2_fill_2
X_8989_ _8989_/Q _9501_/CLK _8989_/D place2464/X VPWR VGND sg13g2_dfrbpq_1
XFILLER_35_44 VPWR VGND sg13g2_fill_1
XFILLER_42_124 VPWR VGND sg13g2_decap_8
XFILLER_70_455 VPWR VGND sg13g2_decap_4
XFILLER_11_500 VPWR VGND sg13g2_decap_4
XFILLER_51_54 VPWR VGND sg13g2_decap_8
X_9524__2856 _9524_/RESET_B VPWR VGND sg13g2_tiehi
XFILLER_4_0 VPWR VGND sg13g2_decap_8
XFILLER_112_619 VPWR VGND sg13g2_decap_8
XFILLER_105_682 VPWR VGND sg13g2_decap_8
XFILLER_120_630 VPWR VGND sg13g2_fill_2
XFILLER_93_558 VPWR VGND sg13g2_fill_2
XFILLER_74_761 VPWR VGND sg13g2_decap_8
XFILLER_58_290 VPWR VGND sg13g2_fill_1
XFILLER_46_441 VPWR VGND sg13g2_decap_8
XFILLER_74_783 VPWR VGND sg13g2_decap_4
XFILLER_19_688 VPWR VGND sg13g2_fill_2
XFILLER_46_474 VPWR VGND sg13g2_decap_8
XFILLER_46_485 VPWR VGND sg13g2_fill_2
XFILLER_61_444 VPWR VGND sg13g2_fill_2
XFILLER_92_83 VPWR VGND sg13g2_fill_1
XFILLER_61_455 VPWR VGND sg13g2_decap_8
XFILLER_21_308 VPWR VGND sg13g2_fill_2
XFILLER_61_499 VPWR VGND sg13g2_fill_2
X_4670_ _9643_/D _4670_/A VPWR VGND sg13g2_inv_1
Xplace2416 place2416/X place2420/X VPWR VGND sg13g2_buf_1
Xplace2405 place2405/X place2408/X VPWR VGND sg13g2_buf_1
Xplace2438 place2438/X place2439/X VPWR VGND sg13g2_buf_1
Xplace2427 place2427/X place2433/X VPWR VGND sg13g2_buf_1
X_6340_ _6342_/B _6371_/A _6371_/B _9376_/Q VPWR VGND sg13g2_o21ai_1
Xplace2449 place2449/X place2450/X VPWR VGND sg13g2_buf_1
XFILLER_6_581 VPWR VGND sg13g2_fill_1
X_6271_ _6271_/Y _6271_/A _6271_/B _6333_/C _8474_/B VPWR VGND sg13g2_nand4_1
Xhold3118 _8271_/A _9136_/Q VPWR VGND sg13g2_dlygate4sd3_1
X_5222_ _5234_/C _5238_/A _9871_/A _5223_/B VPWR VGND sg13g2_nand3_1
Xhold3107 _6463_/B1 _9399_/Q VPWR VGND sg13g2_dlygate4sd3_1
X_8010_ _9015_/D _5369_/C _8009_/A _8009_/Y VPWR VGND sg13g2_o21ai_1
Xhold3129 _8185_/A _9093_/Q VPWR VGND sg13g2_dlygate4sd3_1
X_5153_ _8757_/D _5080_/Y _5349_/C _5288_/B2 _5152_/Y VPWR VGND sg13g2_a22oi_1
XFILLER_69_555 VPWR VGND sg13g2_decap_8
XFILLER_96_385 VPWR VGND sg13g2_decap_4
X_5084_ _5090_/B _5084_/A _5084_/B VPWR VGND sg13g2_nand2_1
X_8912_ _8912_/Q _9603_/CLK _8912_/D place2431/X VPWR VGND sg13g2_dfrbpq_1
XFILLER_65_750 VPWR VGND sg13g2_fill_1
XFILLER_112_27 VPWR VGND sg13g2_decap_8
XFILLER_65_783 VPWR VGND sg13g2_decap_4
X_8843_ _8843_/Q _9251_/CLK _8843_/D place2477/X VPWR VGND sg13g2_dfrbpq_1
XFILLER_37_474 VPWR VGND sg13g2_decap_8
XFILLER_92_580 VPWR VGND sg13g2_decap_8
XFILLER_37_496 VPWR VGND sg13g2_fill_1
X_9574__2816 _9574_/RESET_B VPWR VGND sg13g2_tiehi
X_5986_ _5986_/Y _5986_/A _6004_/B _6004_/C VPWR VGND sg13g2_nand3_1
XFILLER_80_775 VPWR VGND sg13g2_decap_8
X_8774_ _9880_/A _9260_/CLK _8774_/D place2392/X VPWR VGND sg13g2_dfrbpq_1
XFILLER_24_146 VPWR VGND sg13g2_decap_8
XFILLER_40_606 VPWR VGND sg13g2_fill_2
X_9610__2780 _9610_/RESET_B VPWR VGND sg13g2_tiehi
X_7725_ _7727_/C _9169_/Q _7725_/B VPWR VGND sg13g2_nor2_1
X_4937_ _4937_/Y _5012_/A _4937_/B _4937_/C VPWR VGND sg13g2_nand3_1
X_7656_ _7656_/Y _7656_/A _7656_/B _7656_/C _7656_/D VPWR VGND sg13g2_nand4_1
XFILLER_32_190 VPWR VGND sg13g2_decap_8
X_4868_ _4868_/Y _4868_/A _4868_/B VPWR VGND sg13g2_nor2_1
XFILLER_119_741 VPWR VGND sg13g2_decap_8
X_6607_ _6607_/X _6661_/A _9568_/Q _6661_/C VPWR VGND sg13g2_or3_1
X_9326_ _9326_/Q _9410_/CLK _9326_/D place2397/X VPWR VGND sg13g2_dfrbpq_1
XFILLER_119_752 VPWR VGND sg13g2_fill_1
X_7587_ _7591_/B _7759_/A _7799_/B _8976_/Q VPWR VGND sg13g2_nor3_1
X_4799_ _4800_/C _9339_/Q _6010_/A0 VPWR VGND sg13g2_nor2b_1
XFILLER_115_7 VPWR VGND sg13g2_decap_4
X_6538_ _9413_/D _9413_/Q _6538_/A1 _6539_/S VPWR VGND sg13g2_mux2_1
X_9257_ _9257_/Q _9675_/CLK _9257_/D place2444/X VPWR VGND sg13g2_dfrbpq_1
X_6469_ _6469_/Y _8888_/Q _6496_/A2 _6410_/Y _6468_/Y _6467_/Y VPWR VGND sg13g2_a221oi_1
X_8208_ _9104_/D _8222_/A1 _8077_/Y _8207_/Y VPWR VGND sg13g2_o21ai_1
XFILLER_0_702 VPWR VGND sg13g2_fill_1
X_9188_ _9188_/Q _9188_/CLK _9188_/D place2474/X VPWR VGND sg13g2_dfrbpq_1
X_8139_ _8139_/Y _8139_/A _8161_/B VPWR VGND sg13g2_nand2_1
Xhold2940 _7865_/B1 _8940_/Q VPWR VGND sg13g2_dlygate4sd3_1
XFILLER_87_363 VPWR VGND sg13g2_fill_2
Xhold2962 _7849_/B1 _8927_/Q VPWR VGND sg13g2_dlygate4sd3_1
XFILLER_101_151 VPWR VGND sg13g2_decap_8
XFILLER_87_385 VPWR VGND sg13g2_fill_1
XFILLER_75_536 VPWR VGND sg13g2_decap_8
Xhold2973 _6497_/B1 _9404_/Q VPWR VGND sg13g2_dlygate4sd3_1
Xhold2951 _8618_/D _5631_/Y VPWR VGND sg13g2_dlygate4sd3_1
Xhold2984 _6280_/B1 _9368_/Q VPWR VGND sg13g2_dlygate4sd3_1
Xhold2995 _7871_/B1 _8945_/Q VPWR VGND sg13g2_dlygate4sd3_1
XFILLER_56_794 VPWR VGND sg13g2_fill_2
XFILLER_43_400 VPWR VGND sg13g2_decap_8
XFILLER_46_76 VPWR VGND sg13g2_decap_8
XFILLER_71_731 VPWR VGND sg13g2_fill_1
XFILLER_71_720 VPWR VGND sg13g2_decap_8
XFILLER_15_124 VPWR VGND sg13g2_fill_1
XFILLER_16_658 VPWR VGND sg13g2_decap_8
XFILLER_43_433 VPWR VGND sg13g2_decap_4
XFILLER_71_775 VPWR VGND sg13g2_fill_1
XFILLER_43_466 VPWR VGND sg13g2_fill_1
XFILLER_70_274 VPWR VGND sg13g2_decap_4
XFILLER_30_105 VPWR VGND sg13g2_decap_8
XFILLER_109_273 VPWR VGND sg13g2_decap_8
XFILLER_112_416 VPWR VGND sg13g2_decap_8
XFILLER_112_438 VPWR VGND sg13g2_decap_8
XFILLER_97_127 VPWR VGND sg13g2_decap_4
XFILLER_30_7 VPWR VGND sg13g2_decap_8
XFILLER_93_300 VPWR VGND sg13g2_decap_4
XFILLER_93_333 VPWR VGND sg13g2_fill_2
XFILLER_47_761 VPWR VGND sg13g2_decap_8
X_5840_ _5840_/Y _5837_/A2 _9472_/Q VPWR VGND sg13g2_nand2b_1
X_5771_ _5771_/Y _5771_/A1 _9313_/Q _5771_/B1 VPWR VGND sg13g2_a21oi_1
X_4722_ _9688_/D _4722_/A _4722_/B VPWR VGND sg13g2_nor2_1
XFILLER_14_190 VPWR VGND sg13g2_fill_1
X_7510_ _7511_/D _9003_/Q _4550_/Y _7509_/Y VPWR VGND sg13g2_o21ai_1
X_8490_ _8490_/Y _8490_/A _9250_/Q _8490_/C VPWR VGND sg13g2_nand3_1
X_7441_ _7442_/B _9868_/A _5383_/Y _7825_/B1 _7441_/B2 VPWR VGND sg13g2_a22oi_1
X_4653_ _9637_/D _8709_/Q _9637_/Q _6682_/S VPWR VGND sg13g2_a21o_1
Xplace2202 _6558_/D _6939_/B VPWR VGND sg13g2_buf_1
Xplace2213 _6541_/A _9627_/Q VPWR VGND sg13g2_buf_1
XFILLER_116_722 VPWR VGND sg13g2_decap_4
Xplace2246 _7651_/A _7783_/C VPWR VGND sg13g2_buf_1
X_7372_ _7372_/Y _7366_/Y _7371_/Y _7571_/B1 VPWR VGND sg13g2_o21ai_1
X_4584_ _4587_/C _9701_/Q _9694_/Q _9708_/Q VPWR VGND sg13g2_nor3_1
Xplace2224 _7407_/A _9466_/Q VPWR VGND sg13g2_buf_1
Xplace2235 _7431_/A _9466_/Q VPWR VGND sg13g2_buf_1
X_9111_ _9111_/Q _9199_/CLK _9111_/D place2433/X VPWR VGND sg13g2_dfrbpq_1
Xplace2268 _7799_/B _7803_/B VPWR VGND sg13g2_buf_1
X_6323_ _6323_/Y _6509_/A _6509_/B _6323_/C _6438_/A VPWR VGND sg13g2_nand4_1
Xplace2257 _7296_/C _7820_/A VPWR VGND sg13g2_buf_1
Xplace2279 _7644_/B _9464_/Q VPWR VGND sg13g2_buf_1
XFILLER_116_799 VPWR VGND sg13g2_fill_2
XFILLER_116_777 VPWR VGND sg13g2_decap_8
XFILLER_107_16 VPWR VGND sg13g2_fill_1
X_9042_ _9042_/Q clkload6/A _9042_/D place2435/X VPWR VGND sg13g2_dfrbpq_1
X_6254_ _6254_/Y _9247_/Q _6309_/A _6254_/C VPWR VGND sg13g2_nand3_1
XFILLER_103_438 VPWR VGND sg13g2_fill_2
X_5205_ _5205_/Y _5205_/A _5205_/B _5242_/C VPWR VGND sg13g2_nor3_1
X_6185_ _6185_/Y _6371_/A _6371_/B _6185_/B1 VPWR VGND sg13g2_o21ai_1
X_5136_ _5136_/Y _5101_/Y _5118_/A _5117_/Y VPWR VGND sg13g2_o21ai_1
XFILLER_84_311 VPWR VGND sg13g2_fill_2
X_5067_ _7482_/C _7704_/A _5383_/B _7701_/C VPWR VGND sg13g2_nor3_1
XFILLER_38_783 VPWR VGND sg13g2_fill_2
X_9875_ _9875_/X _9875_/A VPWR VGND sg13g2_buf_1
XFILLER_53_742 VPWR VGND sg13g2_fill_1
XFILLER_25_411 VPWR VGND sg13g2_decap_8
XFILLER_37_282 VPWR VGND sg13g2_decap_4
X_8826_ _8826_/Q _9504_/CLK _8826_/D place2430/X VPWR VGND sg13g2_dfrbpq_1
XFILLER_53_775 VPWR VGND sg13g2_fill_2
XFILLER_13_606 VPWR VGND sg13g2_fill_2
XFILLER_25_444 VPWR VGND sg13g2_decap_8
XFILLER_25_466 VPWR VGND sg13g2_fill_1
X_5969_ _5969_/Y _9325_/Q _5981_/B VPWR VGND sg13g2_nand2_1
X_8757_ _9863_/A _9219_/CLK _8757_/D place2392/X VPWR VGND sg13g2_dfrbpq_1
XFILLER_52_263 VPWR VGND sg13g2_fill_1
X_7708_ _7709_/D _9137_/Q _7775_/C _7704_/A VPWR VGND sg13g2_o21ai_1
XFILLER_12_138 VPWR VGND sg13g2_fill_1
X_8688_ _8688_/Q _9630_/CLK _8688_/D fanout946/X VPWR VGND sg13g2_dfrbpq_1
X_7639_ _7641_/A _9217_/Q _7695_/A2 _7794_/B1 _8884_/Q VPWR VGND sg13g2_a22oi_1
X_9309_ _9309_/Q _9409_/CLK _9309_/D place2406/X VPWR VGND sg13g2_dfrbpq_1
XFILLER_106_287 VPWR VGND sg13g2_fill_2
XFILLER_88_661 VPWR VGND sg13g2_decap_8
XFILLER_0_587 VPWR VGND sg13g2_decap_8
XFILLER_48_547 VPWR VGND sg13g2_decap_8
XFILLER_90_303 VPWR VGND sg13g2_decap_8
XFILLER_35_208 VPWR VGND sg13g2_fill_1
XFILLER_113_81 VPWR VGND sg13g2_decap_8
XFILLER_75_399 VPWR VGND sg13g2_decap_4
XFILLER_16_411 VPWR VGND sg13g2_decap_8
XFILLER_16_422 VPWR VGND sg13g2_fill_1
XFILLER_71_572 VPWR VGND sg13g2_decap_8
XFILLER_16_477 VPWR VGND sg13g2_fill_2
XFILLER_43_263 VPWR VGND sg13g2_decap_8
XFILLER_43_274 VPWR VGND sg13g2_fill_1
XFILLER_43_285 VPWR VGND sg13g2_decap_8
XFILLER_31_458 VPWR VGND sg13g2_decap_4
XFILLER_8_665 VPWR VGND sg13g2_decap_8
XFILLER_98_403 VPWR VGND sg13g2_decap_8
XFILLER_98_425 VPWR VGND sg13g2_fill_1
XFILLER_112_268 VPWR VGND sg13g2_fill_2
XFILLER_112_257 VPWR VGND sg13g2_fill_1
XFILLER_112_246 VPWR VGND sg13g2_decap_8
XFILLER_112_235 VPWR VGND sg13g2_decap_8
XFILLER_98_458 VPWR VGND sg13g2_fill_2
XFILLER_79_661 VPWR VGND sg13g2_decap_8
XFILLER_79_650 VPWR VGND sg13g2_decap_8
XFILLER_3_392 VPWR VGND sg13g2_fill_2
XFILLER_120_290 VPWR VGND sg13g2_decap_4
XFILLER_94_664 VPWR VGND sg13g2_decap_4
X_7990_ _9005_/D _5359_/C _8009_/A _7989_/Y VPWR VGND sg13g2_o21ai_1
X_6941_ _6941_/Y _8623_/Q _8622_/Q VPWR VGND sg13g2_nand2b_1
XFILLER_35_720 VPWR VGND sg13g2_decap_8
X_9660_ _9660_/Q _9662_/CLK _9660_/D place2447/X VPWR VGND sg13g2_dfrbpq_1
X_6872_ _9602_/D _6871_/X _9602_/Q _6900_/S VPWR VGND sg13g2_mux2_1
X_5823_ _9304_/D _5823_/A VPWR VGND sg13g2_inv_1
X_9591_ _9591_/Q _9620_/CLK _9591_/D _9591_/RESET_B VPWR VGND sg13g2_dfrbpq_1
X_8611_ _8611_/Q _9689_/CLK _8611_/D fanout961/X VPWR VGND sg13g2_dfrbpq_1
X_8542_ _9264_/D _8534_/C _8538_/Y _8541_/Y VPWR VGND sg13g2_a21oi_1
XFILLER_34_296 VPWR VGND sg13g2_decap_8
X_5754_ _5754_/Y _9317_/Q _5765_/B _5753_/Y VPWR VGND sg13g2_o21ai_1
X_4705_ _9672_/D _4705_/A _4705_/B VPWR VGND sg13g2_nor2_1
X_5685_ _5686_/A _5685_/A1 _5693_/A2 _5693_/B1 _5685_/B2 VPWR VGND sg13g2_a22oi_1
X_8473_ _9241_/D _8486_/A _5355_/C _8472_/Y VPWR VGND sg13g2_o21ai_1
Xplace2021 _6834_/S _6840_/S VPWR VGND sg13g2_buf_1
XFILLER_108_519 VPWR VGND sg13g2_decap_4
X_4636_ _4640_/A _9638_/Q _6742_/D _4635_/Y VPWR VGND sg13g2_o21ai_1
Xplace2010 _6369_/A _6323_/C VPWR VGND sg13g2_buf_1
X_7424_ _7424_/Y _7424_/A _7424_/B _7424_/C _7424_/D VPWR VGND sg13g2_nor4_1
Xplace2043 _8577_/B _5781_/Y VPWR VGND sg13g2_buf_1
Xplace2054 _5586_/B1 _5523_/B1 VPWR VGND sg13g2_buf_1
X_7355_ _7358_/C _7831_/C _7650_/C _8838_/Q VPWR VGND sg13g2_nand3_1
Xplace2032 _6455_/A _6044_/C VPWR VGND sg13g2_buf_1
X_4567_ _4567_/Y _4567_/A hold2990/X VPWR VGND sg13g2_nor2b_1
Xplace2087 _5765_/B _5739_/A VPWR VGND sg13g2_buf_1
XFILLER_89_414 VPWR VGND sg13g2_decap_8
Xplace2065 _8346_/A1 _8344_/A1 VPWR VGND sg13g2_buf_1
Xplace2076 _8100_/A1 _5343_/Y VPWR VGND sg13g2_buf_1
X_6306_ _6306_/Y _9238_/Q _6144_/D _6509_/B VPWR VGND sg13g2_o21ai_1
XFILLER_104_736 VPWR VGND sg13g2_fill_1
X_7286_ _7286_/Y _7286_/A _7286_/B _7286_/C _7286_/D VPWR VGND sg13g2_nand4_1
X_4498_ _8498_/C _7431_/A _7705_/A _7705_/B VPWR VGND sg13g2_nor3_1
Xplace2098 _7385_/B _7411_/B VPWR VGND sg13g2_buf_1
XFILLER_104_769 VPWR VGND sg13g2_fill_1
XFILLER_104_758 VPWR VGND sg13g2_decap_8
XFILLER_77_609 VPWR VGND sg13g2_fill_2
X_9025_ _9025_/Q _9153_/CLK _9025_/D place2497/X VPWR VGND sg13g2_dfrbpq_1
X_6237_ _6238_/C _6262_/B _6237_/B VPWR VGND sg13g2_or2_1
XFILLER_85_620 VPWR VGND sg13g2_decap_4
X_6168_ _6168_/X _8970_/Q _9032_/Q _9094_/Q _9156_/Q _6400_/S0 _6400_/S1 VPWR VGND
+ sg13g2_mux4_1
X_5119_ _5120_/B _5119_/A _5119_/B VPWR VGND sg13g2_or2_1
XFILLER_85_675 VPWR VGND sg13g2_decap_8
XFILLER_57_366 VPWR VGND sg13g2_decap_8
X_6099_ _6509_/C _9245_/Q _6451_/B VPWR VGND sg13g2_nor2_1
XFILLER_27_12 VPWR VGND sg13g2_fill_1
XFILLER_85_697 VPWR VGND sg13g2_fill_1
X_9858_ _9858_/X _9858_/A VPWR VGND sg13g2_buf_1
XFILLER_26_764 VPWR VGND sg13g2_decap_8
X_8809_ _8809_/Q _9304_/CLK _8809_/D place2415/X VPWR VGND sg13g2_dfrbpq_1
XFILLER_53_572 VPWR VGND sg13g2_fill_1
XFILLER_25_274 VPWR VGND sg13g2_decap_4
XFILLER_43_88 VPWR VGND sg13g2_decap_8
XFILLER_5_635 VPWR VGND sg13g2_fill_2
XFILLER_104_0 VPWR VGND sg13g2_decap_8
XFILLER_108_70 VPWR VGND sg13g2_decap_8
XFILLER_107_585 VPWR VGND sg13g2_decap_4
XFILLER_4_49 VPWR VGND sg13g2_decap_8
XFILLER_103_780 VPWR VGND sg13g2_fill_2
XFILLER_0_373 VPWR VGND sg13g2_decap_8
XFILLER_48_344 VPWR VGND sg13g2_fill_2
XFILLER_63_325 VPWR VGND sg13g2_decap_8
XFILLER_36_528 VPWR VGND sg13g2_fill_1
XFILLER_17_764 VPWR VGND sg13g2_fill_1
XFILLER_32_701 VPWR VGND sg13g2_decap_8
XFILLER_71_391 VPWR VGND sg13g2_fill_1
XFILLER_31_244 VPWR VGND sg13g2_fill_2
XFILLER_8_473 VPWR VGND sg13g2_decap_8
X_5470_ _8693_/D _5470_/A _5472_/B_N VPWR VGND sg13g2_nor2b_1
X_4421_ _4422_/C _9248_/Q _9246_/Q VPWR VGND sg13g2_nor2_1
XFILLER_99_701 VPWR VGND sg13g2_decap_4
X_4352_ _7002_/C _4506_/B _4506_/C VPWR VGND sg13g2_and2_1
X_7140_ _7140_/Y _7892_/D _6977_/Y _7132_/Y _4436_/D VPWR VGND sg13g2_a22oi_1
XFILLER_99_756 VPWR VGND sg13g2_fill_2
XFILLER_59_609 VPWR VGND sg13g2_fill_1
X_7071_ _7071_/Y _7168_/B _7172_/B _7080_/C VPWR VGND sg13g2_nand3_1
XFILLER_113_599 VPWR VGND sg13g2_decap_8
X_6022_ _6044_/A _8589_/A _6338_/B VPWR VGND sg13g2_nand2b_1
X_9537__2843 _9537_/RESET_B VPWR VGND sg13g2_tiehi
XFILLER_94_450 VPWR VGND sg13g2_decap_8
XFILLER_67_686 VPWR VGND sg13g2_decap_8
XFILLER_39_377 VPWR VGND sg13g2_decap_8
X_7973_ _7973_/Y _7975_/A _8997_/Q _8365_/C VPWR VGND sg13g2_nand3_1
XFILLER_81_155 VPWR VGND sg13g2_decap_8
X_6924_ _6924_/X _9708_/Q _9632_/Q _6939_/B VPWR VGND sg13g2_and3_1
X_9643_ _9643_/Q _9645_/CLK _9643_/D fanout976/X VPWR VGND sg13g2_dfrbpq_1
XFILLER_81_177 VPWR VGND sg13g2_fill_2
XFILLER_120_49 VPWR VGND sg13g2_decap_8
X_6855_ _6855_/X _8901_/Q _8933_/Q _6905_/S VPWR VGND sg13g2_mux2_1
XFILLER_50_542 VPWR VGND sg13g2_decap_4
XFILLER_23_734 VPWR VGND sg13g2_decap_8
X_5806_ _5807_/A _9296_/Q _8579_/A2 _8579_/B1 _9493_/Q VPWR VGND sg13g2_a22oi_1
X_9574_ _9574_/Q _9582_/CLK _9574_/D _9574_/RESET_B VPWR VGND sg13g2_dfrbpq_1
X_6786_ _9545_/D _9545_/Q _9634_/Q _6786_/S VPWR VGND sg13g2_mux2_1
XFILLER_22_277 VPWR VGND sg13g2_decap_8
X_5737_ _5737_/Y _5762_/A1 _5740_/A2 _5735_/Y _5736_/Y VPWR VGND sg13g2_a22oi_1
X_8525_ _9262_/D _8525_/A VPWR VGND sg13g2_inv_1
XFILLER_50_597 VPWR VGND sg13g2_decap_4
X_8456_ _8456_/Y _8458_/A _9233_/Q _8474_/C VPWR VGND sg13g2_nand3_1
XFILLER_108_349 VPWR VGND sg13g2_fill_1
X_7407_ _7407_/Y _7407_/A _7407_/B _7407_/C _7407_/D VPWR VGND sg13g2_nor4_1
X_5668_ _8606_/D _5668_/A VPWR VGND sg13g2_inv_1
X_5599_ _8654_/D _5598_/Y _5597_/Y _5602_/B1 VPWR VGND sg13g2_a21oi_1
X_8387_ _8387_/Y _8401_/A _9194_/Q _8399_/C VPWR VGND sg13g2_nand3_1
X_4619_ _5491_/C _9684_/Q _9687_/Q _9686_/Q VPWR VGND sg13g2_nor3_1
XFILLER_2_605 VPWR VGND sg13g2_decap_4
X_7338_ _7340_/A _9278_/Q _7557_/A2 _7557_/B1 _9310_/Q VPWR VGND sg13g2_a22oi_1
XFILLER_104_522 VPWR VGND sg13g2_fill_1
XFILLER_8_7 VPWR VGND sg13g2_decap_8
XFILLER_104_544 VPWR VGND sg13g2_decap_4
X_7269_ _7269_/X _7269_/A _7482_/C VPWR VGND sg13g2_and2_1
Xfanout942 _5934_/A1 master_rvalid_i VPWR VGND sg13g2_buf_1
X_9008_ _9008_/Q clkload7/A _9008_/D place2464/X VPWR VGND sg13g2_dfrbpq_1
Xfanout975 fanout975/X fanout976/X VPWR VGND sg13g2_buf_1
Xfanout964 fanout964/X fanout967/X VPWR VGND sg13g2_buf_1
Xfanout953 fanout953/X fanout954/X VPWR VGND sg13g2_buf_1
Xfanout986 _4590_/C _4743_/A VPWR VGND sg13g2_buf_1
XFILLER_38_33 VPWR VGND sg13g2_fill_2
XFILLER_73_612 VPWR VGND sg13g2_decap_8
XFILLER_73_623 VPWR VGND sg13g2_fill_2
XFILLER_58_697 VPWR VGND sg13g2_decap_8
XFILLER_72_155 VPWR VGND sg13g2_decap_8
XFILLER_72_133 VPWR VGND sg13g2_fill_2
XFILLER_54_32 VPWR VGND sg13g2_decap_8
XFILLER_72_166 VPWR VGND sg13g2_fill_1
XFILLER_13_200 VPWR VGND sg13g2_fill_2
XFILLER_14_712 VPWR VGND sg13g2_decap_4
XFILLER_26_572 VPWR VGND sg13g2_fill_1
XFILLER_26_594 VPWR VGND sg13g2_fill_2
XFILLER_41_564 VPWR VGND sg13g2_decap_8
XFILLER_41_575 VPWR VGND sg13g2_fill_1
X_9587__2803 _9587_/RESET_B VPWR VGND sg13g2_tiehi
Xclkload18 clkload18/Y _9672_/CLK VPWR VGND sg13g2_inv_2
XFILLER_70_97 VPWR VGND sg13g2_fill_1
Xclkload29 clkload29/Y _9678_/CLK VPWR VGND sg13g2_inv_8
XFILLER_79_40 VPWR VGND sg13g2_decap_4
XFILLER_110_503 VPWR VGND sg13g2_decap_4
XFILLER_95_50 VPWR VGND sg13g2_decap_8
XFILLER_49_631 VPWR VGND sg13g2_decap_4
XFILLER_1_693 VPWR VGND sg13g2_decap_8
XFILLER_49_664 VPWR VGND sg13g2_decap_8
XFILLER_64_612 VPWR VGND sg13g2_decap_4
XFILLER_91_464 VPWR VGND sg13g2_decap_4
XFILLER_36_369 VPWR VGND sg13g2_decap_8
XFILLER_48_196 VPWR VGND sg13g2_fill_1
XFILLER_64_689 VPWR VGND sg13g2_decap_8
XFILLER_17_550 VPWR VGND sg13g2_decap_8
X_4970_ _4971_/B _4821_/Y _4969_/Y _4968_/Y VPWR VGND sg13g2_o21ai_1
XFILLER_44_380 VPWR VGND sg13g2_decap_8
X_6640_ _9443_/D _6653_/A1 _6639_/Y _6638_/Y VPWR VGND sg13g2_o21ai_1
X_6571_ _6571_/Y _9423_/Q _6671_/B VPWR VGND sg13g2_nand2_1
X_5522_ _5522_/Y _5525_/A _5525_/B _8630_/Q _5525_/D VPWR VGND sg13g2_nand4_1
X_8310_ _9155_/D _8314_/A1 _8047_/Y _8309_/Y VPWR VGND sg13g2_o21ai_1
X_9290_ _9290_/Q _9410_/CLK _9290_/D place2395/X VPWR VGND sg13g2_dfrbpq_1
XFILLER_9_793 VPWR VGND sg13g2_fill_1
X_5453_ _5454_/A _5455_/A1 _8685_/Q _8686_/Q _5469_/B2 VPWR VGND sg13g2_a22oi_1
X_8241_ _8241_/Y _8241_/A _8243_/B VPWR VGND sg13g2_nand2_1
XFILLER_117_179 VPWR VGND sg13g2_fill_1
X_5384_ _5384_/Y _7808_/B1 _7771_/A2 _5784_/D VPWR VGND sg13g2_o21ai_1
X_4404_ _8669_/D _4404_/A _5472_/B_N VPWR VGND sg13g2_nor2b_1
X_8172_ _9086_/D _8198_/A1 _8029_/Y _8171_/Y VPWR VGND sg13g2_o21ai_1
X_4335_ _4481_/B _9653_/Q VPWR VGND sg13g2_inv_1
XFILLER_113_341 VPWR VGND sg13g2_decap_4
XFILLER_99_553 VPWR VGND sg13g2_decap_4
Xoutput2699 master_wdata_o[10] _5725_/Y VPWR VGND sg13g2_buf_1
Xoutput2677 master_addr_o[24] _9882_/X VPWR VGND sg13g2_buf_1
Xoutput2666 master_addr_o[14] _9872_/X VPWR VGND sg13g2_buf_1
Xoutput2688 master_addr_o[5] _9863_/X VPWR VGND sg13g2_buf_1
X_7123_ _7123_/Y _7228_/B _7221_/B _7123_/C VPWR VGND sg13g2_nand3_1
XFILLER_87_715 VPWR VGND sg13g2_decap_8
XFILLER_86_214 VPWR VGND sg13g2_fill_1
XFILLER_115_38 VPWR VGND sg13g2_decap_8
X_7054_ _8838_/D _7056_/A _7052_/Y _7053_/Y VPWR VGND sg13g2_o21ai_1
X_6005_ _6005_/Y _8528_/C _5375_/C _6004_/Y VPWR VGND sg13g2_o21ai_1
XFILLER_86_269 VPWR VGND sg13g2_decap_8
XFILLER_74_409 VPWR VGND sg13g2_fill_2
XFILLER_67_494 VPWR VGND sg13g2_decap_4
XFILLER_55_645 VPWR VGND sg13g2_decap_8
XFILLER_54_177 VPWR VGND sg13g2_decap_4
XFILLER_42_317 VPWR VGND sg13g2_decap_8
X_7956_ _7956_/Y _7956_/A _8989_/Q _8391_/C VPWR VGND sg13g2_nand3_1
X_6907_ _6907_/X _8823_/Q _8824_/Q _9255_/Q VPWR VGND sg13g2_mux2_1
X_7887_ _8959_/D _5344_/C _7899_/A _7886_/Y VPWR VGND sg13g2_o21ai_1
XFILLER_23_542 VPWR VGND sg13g2_fill_1
X_6838_ _9586_/D _9619_/Q _9586_/Q _6839_/S VPWR VGND sg13g2_mux2_1
XFILLER_50_350 VPWR VGND sg13g2_fill_2
XFILLER_23_564 VPWR VGND sg13g2_decap_8
X_9626_ _9626_/Q _9701_/CLK _9626_/D fanout952/X VPWR VGND sg13g2_dfrbpq_1
X_9557_ _9557_/Q _9587_/CLK _9557_/D _9557_/RESET_B VPWR VGND sg13g2_dfrbpq_1
XFILLER_50_372 VPWR VGND sg13g2_fill_1
X_6769_ _9528_/D _9528_/Q _9438_/Q _6786_/S VPWR VGND sg13g2_mux2_1
X_8508_ _8510_/B _9256_/Q _9257_/Q VPWR VGND sg13g2_nand2_1
X_9488_ _9488_/Q _9621_/CLK _9488_/D _9488_/RESET_B VPWR VGND sg13g2_dfrbpq_1
XFILLER_109_636 VPWR VGND sg13g2_fill_1
XFILLER_109_669 VPWR VGND sg13g2_fill_1
X_8439_ _9224_/D _8448_/A _8439_/A2 _8438_/Y VPWR VGND sg13g2_o21ai_1
XFILLER_123_105 VPWR VGND sg13g2_fill_2
XFILLER_49_21 VPWR VGND sg13g2_fill_2
XFILLER_49_98 VPWR VGND sg13g2_fill_2
XFILLER_92_206 VPWR VGND sg13g2_decap_8
XFILLER_1_28 VPWR VGND sg13g2_decap_8
XFILLER_46_623 VPWR VGND sg13g2_fill_1
XFILLER_45_133 VPWR VGND sg13g2_fill_1
XFILLER_73_475 VPWR VGND sg13g2_fill_2
XFILLER_73_497 VPWR VGND sg13g2_decap_8
XFILLER_45_199 VPWR VGND sg13g2_decap_8
XFILLER_14_575 VPWR VGND sg13g2_fill_2
XFILLER_81_74 VPWR VGND sg13g2_decap_8
XFILLER_14_597 VPWR VGND sg13g2_fill_2
Xplace1908 _7459_/A _5377_/X VPWR VGND sg13g2_buf_1
Xclkbuf_leaf_13_clk_i _9615_/CLK clkload3/A VPWR VGND sg13g2_buf_16
XFILLER_115_639 VPWR VGND sg13g2_decap_8
XFILLER_114_105 VPWR VGND sg13g2_fill_2
Xplace1919 _6523_/A _4532_/B VPWR VGND sg13g2_buf_1
Xclkbuf_leaf_28_clk_i clkload4/A clkbuf_3_0__f_clk_i/X VPWR VGND sg13g2_buf_16
XFILLER_96_589 VPWR VGND sg13g2_fill_1
XFILLER_77_770 VPWR VGND sg13g2_decap_4
XFILLER_49_472 VPWR VGND sg13g2_decap_4
X_7810_ _7811_/D _7810_/A _7810_/B _7810_/C _7810_/D VPWR VGND sg13g2_and4_1
XFILLER_64_420 VPWR VGND sg13g2_decap_4
XFILLER_36_122 VPWR VGND sg13g2_decap_8
XFILLER_91_250 VPWR VGND sg13g2_decap_8
X_8790_ _8790_/Q _9254_/CLK _8790_/D place2423/X VPWR VGND sg13g2_dfrbpq_1
XFILLER_64_475 VPWR VGND sg13g2_fill_1
XFILLER_37_678 VPWR VGND sg13g2_fill_1
X_7741_ _7741_/Y _9077_/Q _7741_/B _7747_/A VPWR VGND sg13g2_nand3b_1
X_4953_ _4953_/Y _4883_/A _9366_/Q VPWR VGND sg13g2_nand2b_1
X_7672_ _7672_/Y _7672_/A _7672_/B _7672_/C _7672_/D VPWR VGND sg13g2_nor4_1
X_9487__2893 _9487_/RESET_B VPWR VGND sg13g2_tiehi
X_6623_ _6623_/Y _8640_/Q _6666_/A2 _6622_/X VPWR VGND sg13g2_o21ai_1
X_9411_ _9411_/Q _9414_/CLK _9411_/D place2500/X VPWR VGND sg13g2_dfrbpq_1
X_4884_ _4884_/X _4945_/A _4945_/C VPWR VGND sg13g2_and2_1
X_9342_ _9342_/Q _9414_/CLK _9342_/D place2504/X VPWR VGND sg13g2_dfrbpq_1
X_6554_ _6554_/X _6558_/A _9419_/Q _6737_/A _6558_/D VPWR VGND sg13g2_and4_1
X_9273_ _9273_/Q _9304_/CLK _9273_/D place2420/X VPWR VGND sg13g2_dfrbpq_1
X_6485_ _6485_/Y _9017_/Q _6506_/A2 _6507_/A2 _9203_/Q VPWR VGND sg13g2_a22oi_1
X_5505_ _5506_/B _8624_/Q _5499_/Y _5497_/Y VPWR VGND sg13g2_o21ai_1
X_5436_ _8674_/D _5436_/A _5438_/B_N VPWR VGND sg13g2_nor2b_1
X_8224_ _9112_/D _5836_/D _7954_/Y _8223_/Y VPWR VGND sg13g2_o21ai_1
X_8155_ _8155_/Y _9078_/Q _8159_/B VPWR VGND sg13g2_nand2_1
X_5367_ _8807_/D _8563_/B _5375_/B _5367_/C _5375_/D VPWR VGND sg13g2_nor4_1
XFILLER_101_300 VPWR VGND sg13g2_decap_8
X_5298_ _5301_/A _5293_/Y _5315_/B _5306_/B VPWR VGND sg13g2_o21ai_1
X_8086_ _8086_/Y _8086_/A _9495_/Q _8095_/C _8086_/D VPWR VGND sg13g2_nand4_1
X_7106_ _7106_/Y _5366_/C _7130_/A2 _7105_/Y VPWR VGND sg13g2_o21ai_1
X_4318_ _4880_/D _9342_/Q VPWR VGND sg13g2_inv_1
XFILLER_101_344 VPWR VGND sg13g2_fill_2
XFILLER_87_589 VPWR VGND sg13g2_fill_1
X_7037_ _7037_/Y _8022_/D _6966_/Y _7036_/X _4436_/B VPWR VGND sg13g2_a22oi_1
XFILLER_55_442 VPWR VGND sg13g2_decap_4
X_8988_ _8988_/Q _9251_/CLK _8988_/D place2461/X VPWR VGND sg13g2_dfrbpq_1
X_7939_ _8981_/D _5275_/Y _7948_/A _7938_/Y VPWR VGND sg13g2_o21ai_1
XFILLER_70_478 VPWR VGND sg13g2_decap_8
XFILLER_70_489 VPWR VGND sg13g2_fill_2
X_9609_ _9609_/Q _9615_/CLK _9609_/D _9609_/RESET_B VPWR VGND sg13g2_dfrbpq_1
XFILLER_51_33 VPWR VGND sg13g2_fill_2
XFILLER_109_488 VPWR VGND sg13g2_fill_1
XFILLER_109_477 VPWR VGND sg13g2_decap_8
XFILLER_3_722 VPWR VGND sg13g2_decap_8
XFILLER_2_221 VPWR VGND sg13g2_fill_2
XFILLER_97_309 VPWR VGND sg13g2_decap_4
XFILLER_78_512 VPWR VGND sg13g2_fill_2
XFILLER_78_501 VPWR VGND sg13g2_decap_8
XFILLER_78_523 VPWR VGND sg13g2_fill_1
XFILLER_116_70 VPWR VGND sg13g2_fill_2
XFILLER_93_504 VPWR VGND sg13g2_fill_2
XFILLER_76_74 VPWR VGND sg13g2_decap_4
XFILLER_58_280 VPWR VGND sg13g2_fill_1
XFILLER_18_111 VPWR VGND sg13g2_fill_1
XFILLER_18_122 VPWR VGND sg13g2_fill_1
XFILLER_74_795 VPWR VGND sg13g2_fill_2
XFILLER_73_250 VPWR VGND sg13g2_decap_8
XFILLER_33_103 VPWR VGND sg13g2_decap_8
Xplace2417 place2417/X place2420/X VPWR VGND sg13g2_buf_1
Xplace2406 place2406/X place2408/X VPWR VGND sg13g2_buf_1
Xplace2428 place2428/X place2430/X VPWR VGND sg13g2_buf_1
Xplace2439 place2439/X place2452/X VPWR VGND sg13g2_buf_1
X_6270_ _6270_/Y _6271_/B _6333_/C _6270_/C VPWR VGND sg13g2_nor3_1
Xhold3119 _6617_/A _9437_/Q VPWR VGND sg13g2_dlygate4sd3_1
X_5221_ _5224_/A _5217_/Y _5242_/C _4320_/Y VPWR VGND sg13g2_o21ai_1
Xhold3108 _8319_/A _9160_/Q VPWR VGND sg13g2_dlygate4sd3_1
XFILLER_123_491 VPWR VGND sg13g2_decap_4
X_5152_ _5152_/Y _5152_/A _5192_/B VPWR VGND sg13g2_xnor2_1
XFILLER_69_512 VPWR VGND sg13g2_fill_1
XFILLER_111_664 VPWR VGND sg13g2_decap_8
XFILLER_96_342 VPWR VGND sg13g2_decap_8
XFILLER_69_567 VPWR VGND sg13g2_decap_4
XFILLER_110_174 VPWR VGND sg13g2_decap_8
XFILLER_110_163 VPWR VGND sg13g2_fill_1
X_5083_ _5084_/B _5083_/A _8530_/B _5083_/C _8530_/A VPWR VGND sg13g2_nand4_1
X_8911_ _8911_/Q _9611_/CLK _8911_/D place2416/X VPWR VGND sg13g2_dfrbpq_1
XFILLER_2_93 VPWR VGND sg13g2_fill_1
XFILLER_37_431 VPWR VGND sg13g2_fill_1
XFILLER_71_209 VPWR VGND sg13g2_decap_8
X_8842_ _8842_/Q _9251_/CLK _8842_/D place2477/X VPWR VGND sg13g2_dfrbpq_1
X_8773_ _9879_/A _9260_/CLK _8773_/D place2391/X VPWR VGND sg13g2_dfrbpq_1
XFILLER_52_412 VPWR VGND sg13g2_decap_8
X_5985_ _9330_/D _5984_/Y _9330_/Q _6003_/S VPWR VGND sg13g2_mux2_1
XFILLER_80_754 VPWR VGND sg13g2_decap_8
X_7724_ _7727_/B _9200_/Q _7724_/B VPWR VGND sg13g2_nor2_1
XFILLER_52_445 VPWR VGND sg13g2_fill_2
XFILLER_40_618 VPWR VGND sg13g2_decap_8
XFILLER_52_489 VPWR VGND sg13g2_decap_8
XFILLER_33_692 VPWR VGND sg13g2_fill_2
X_4936_ _4937_/B _4844_/B _4791_/B _4913_/A VPWR VGND sg13g2_o21ai_1
X_7655_ _7656_/D _9266_/Q _8515_/D VPWR VGND sg13g2_nand2_1
X_4867_ _4868_/B _5008_/A _9355_/Q VPWR VGND sg13g2_nor2b_1
XFILLER_119_720 VPWR VGND sg13g2_decap_8
X_6606_ _6606_/Y _6606_/A _6654_/B VPWR VGND sg13g2_nand2_1
X_7586_ _7586_/Y _7586_/A _7586_/B _7586_/C _7586_/D VPWR VGND sg13g2_nor4_1
X_9325_ _9325_/Q _9409_/CLK _9325_/D place2396/X VPWR VGND sg13g2_dfrbpq_1
X_6537_ _9412_/D _9412_/Q _6537_/A1 _6539_/S VPWR VGND sg13g2_mux2_1
XFILLER_21_36 VPWR VGND sg13g2_fill_2
X_4798_ _4798_/Y _4750_/B _4945_/B _4939_/A2 VPWR VGND sg13g2_o21ai_1
XFILLER_21_47 VPWR VGND sg13g2_fill_2
XFILLER_97_29 VPWR VGND sg13g2_fill_1
X_9256_ _9256_/Q _9675_/CLK _9256_/D place2444/X VPWR VGND sg13g2_dfrbpq_1
X_6468_ _6468_/Y _6271_/B _6104_/Y _6408_/B VPWR VGND sg13g2_o21ai_1
X_8207_ _8207_/Y _9104_/Q _8221_/B VPWR VGND sg13g2_nand2_1
X_6399_ _6399_/Y _6399_/A _6399_/B _6399_/C _6399_/D VPWR VGND sg13g2_nor4_1
X_9187_ _9187_/Q clkload4/A _9187_/D place2481/X VPWR VGND sg13g2_dfrbpq_1
X_5419_ _5419_/Y _8618_/Q _4457_/X _5418_/Y _8697_/Q _9706_/Q VPWR VGND sg13g2_a221oi_1
X_8138_ _9069_/D _8156_/A1 _7928_/Y _8137_/Y VPWR VGND sg13g2_o21ai_1
XFILLER_0_747 VPWR VGND sg13g2_decap_4
Xhold2930 _8706_/D _8705_/Q VPWR VGND sg13g2_dlygate4sd3_1
XFILLER_102_664 VPWR VGND sg13g2_decap_8
XFILLER_101_130 VPWR VGND sg13g2_decap_8
Xhold2941 _6166_/B1 _9354_/Q VPWR VGND sg13g2_dlygate4sd3_1
XFILLER_102_675 VPWR VGND sg13g2_fill_2
Xhold2963 _7861_/B1 _8937_/Q VPWR VGND sg13g2_dlygate4sd3_1
XFILLER_87_397 VPWR VGND sg13g2_fill_1
XFILLER_75_515 VPWR VGND sg13g2_decap_8
X_8069_ _9039_/D _8102_/A1 _8068_/Y _8067_/Y VPWR VGND sg13g2_o21ai_1
XFILLER_48_729 VPWR VGND sg13g2_fill_1
Xhold2952 _6329_/B1 _9374_/Q VPWR VGND sg13g2_dlygate4sd3_1
Xhold2974 _6395_/B1 _9387_/Q VPWR VGND sg13g2_dlygate4sd3_1
Xhold2985 _6209_/B1 _9360_/Q VPWR VGND sg13g2_dlygate4sd3_1
Xhold2996 _6195_/B1 _9357_/Q VPWR VGND sg13g2_dlygate4sd3_1
XFILLER_83_570 VPWR VGND sg13g2_decap_4
XFILLER_46_55 VPWR VGND sg13g2_decap_8
XFILLER_83_581 VPWR VGND sg13g2_decap_4
XFILLER_70_220 VPWR VGND sg13g2_decap_8
XFILLER_16_637 VPWR VGND sg13g2_decap_4
XFILLER_28_497 VPWR VGND sg13g2_fill_1
XFILLER_46_99 VPWR VGND sg13g2_decap_4
XFILLER_30_117 VPWR VGND sg13g2_decap_4
XFILLER_31_629 VPWR VGND sg13g2_decap_8
XFILLER_24_692 VPWR VGND sg13g2_decap_8
XFILLER_30_139 VPWR VGND sg13g2_decap_4
XFILLER_11_386 VPWR VGND sg13g2_decap_4
XFILLER_7_49 VPWR VGND sg13g2_decap_8
XFILLER_105_480 VPWR VGND sg13g2_decap_8
XFILLER_120_483 VPWR VGND sg13g2_decap_4
XFILLER_93_312 VPWR VGND sg13g2_fill_2
Xclkbuf_leaf_13_jtag_tck_i_regs _9630_/CLK clkbuf_leaf_1_jtag_tck_i_regs/A VPWR VGND
+ sg13g2_buf_16
XFILLER_66_559 VPWR VGND sg13g2_decap_4
XFILLER_81_507 VPWR VGND sg13g2_decap_4
XFILLER_53_209 VPWR VGND sg13g2_fill_1
XFILLER_47_773 VPWR VGND sg13g2_decap_8
XFILLER_34_401 VPWR VGND sg13g2_decap_4
XFILLER_74_592 VPWR VGND sg13g2_decap_8
XFILLER_19_486 VPWR VGND sg13g2_decap_8
XFILLER_46_283 VPWR VGND sg13g2_decap_8
X_5770_ _5770_/Y _9321_/Q _5769_/B _5769_/Y VPWR VGND sg13g2_o21ai_1
XFILLER_61_264 VPWR VGND sg13g2_decap_8
XFILLER_34_478 VPWR VGND sg13g2_decap_8
X_4721_ _4722_/B _9688_/Q _4721_/B VPWR VGND sg13g2_nor2_1
X_4652_ _9638_/D _4652_/A _6682_/S VPWR VGND sg13g2_nor2_1
X_7440_ _7442_/A _9221_/Q _5380_/Y _7680_/B1 _8874_/Q VPWR VGND sg13g2_a22oi_1
Xplace2203 _6939_/B _6937_/B VPWR VGND sg13g2_buf_1
XFILLER_116_701 VPWR VGND sg13g2_decap_8
X_9110_ _9110_/Q _9198_/CLK _9110_/D place2436/X VPWR VGND sg13g2_dfrbpq_1
Xplace2225 _7489_/A _7299_/A VPWR VGND sg13g2_buf_1
X_4583_ _9698_/D _4590_/C hold2936/X VPWR VGND sg13g2_nor2b_1
X_7371_ _7371_/Y _7407_/A _7371_/B _7371_/C _7371_/D VPWR VGND sg13g2_nor4_1
Xplace2236 _7369_/C _7404_/C VPWR VGND sg13g2_buf_1
Xplace2214 _5629_/C _9627_/Q VPWR VGND sg13g2_buf_1
XFILLER_115_222 VPWR VGND sg13g2_decap_4
Xplace2258 _7705_/A _7644_/A VPWR VGND sg13g2_buf_1
Xplace2269 _7803_/B _7783_/B VPWR VGND sg13g2_buf_1
Xplace2247 _7783_/C _7747_/A VPWR VGND sg13g2_buf_1
X_6322_ _6509_/A _9240_/Q _6322_/B VPWR VGND sg13g2_nand2b_1
XFILLER_115_266 VPWR VGND sg13g2_decap_4
X_9041_ _9041_/Q _9199_/CLK _9041_/D place2427/X VPWR VGND sg13g2_dfrbpq_1
X_6253_ _9366_/D _6252_/Y _9366_/Q _6253_/S VPWR VGND sg13g2_mux2_1
X_5204_ _5207_/A _5205_/B _5242_/C _5205_/A VPWR VGND sg13g2_o21ai_1
XFILLER_85_802 VPWR VGND sg13g2_fill_2
XFILLER_69_353 VPWR VGND sg13g2_decap_4
X_6184_ _6184_/Y _6182_/Y _6183_/Y _6044_/C VPWR VGND sg13g2_a21oi_1
XFILLER_111_461 VPWR VGND sg13g2_fill_2
X_5135_ _5135_/Y _5134_/B _5119_/A _5118_/B VPWR VGND sg13g2_a21oi_1
XFILLER_57_526 VPWR VGND sg13g2_decap_8
XFILLER_123_49 VPWR VGND sg13g2_decap_8
X_5066_ _5066_/Y _5085_/C _5066_/B VPWR VGND sg13g2_xnor2_1
X_9874_ _9874_/X _9874_/A VPWR VGND sg13g2_buf_1
XFILLER_53_732 VPWR VGND sg13g2_fill_1
XFILLER_16_14 VPWR VGND sg13g2_fill_1
X_8825_ _8825_/Q _9504_/CLK _8825_/D place2430/X VPWR VGND sg13g2_dfrbpq_1
XFILLER_52_231 VPWR VGND sg13g2_fill_2
X_5968_ _5968_/Y _9490_/Q _5980_/A2 _5857_/X _5980_/B2 VPWR VGND sg13g2_a22oi_1
X_8756_ _9862_/A _9219_/CLK _8756_/D place2392/X VPWR VGND sg13g2_dfrbpq_1
XFILLER_12_117 VPWR VGND sg13g2_fill_1
XFILLER_40_415 VPWR VGND sg13g2_decap_4
XFILLER_40_426 VPWR VGND sg13g2_fill_2
X_7707_ _7709_/C _9168_/Q _7767_/B VPWR VGND sg13g2_nor2_1
X_4919_ _4919_/Y _4903_/Y _4918_/Y _5006_/A1 VPWR VGND sg13g2_a21oi_1
X_5899_ _5901_/A _5899_/A1 _5952_/A _5898_/Y VPWR VGND sg13g2_o21ai_1
X_8687_ _8687_/Q _9630_/CLK _8687_/D fanout945/X VPWR VGND sg13g2_dfrbpq_1
X_7638_ _8915_/D _8915_/Q _7637_/Y _7774_/S VPWR VGND sg13g2_mux2_1
XFILLER_20_183 VPWR VGND sg13g2_decap_4
XFILLER_32_57 VPWR VGND sg13g2_fill_1
XFILLER_119_550 VPWR VGND sg13g2_decap_4
X_7569_ _7570_/D _9068_/Q _4529_/Y _7566_/X VPWR VGND sg13g2_o21ai_1
X_9308_ _9308_/Q _9409_/CLK _9308_/D place2393/X VPWR VGND sg13g2_dfrbpq_1
XFILLER_4_349 VPWR VGND sg13g2_decap_4
XFILLER_122_715 VPWR VGND sg13g2_fill_1
XFILLER_122_704 VPWR VGND sg13g2_decap_8
XFILLER_107_789 VPWR VGND sg13g2_fill_1
X_9239_ _9239_/Q clkload4/A _9239_/D place2480/X VPWR VGND sg13g2_dfrbpq_1
XFILLER_76_802 VPWR VGND sg13g2_fill_2
XFILLER_102_472 VPWR VGND sg13g2_decap_8
XFILLER_87_161 VPWR VGND sg13g2_decap_4
XFILLER_0_566 VPWR VGND sg13g2_decap_8
XFILLER_57_76 VPWR VGND sg13g2_decap_4
XFILLER_75_356 VPWR VGND sg13g2_fill_2
XFILLER_90_359 VPWR VGND sg13g2_decap_8
XFILLER_16_456 VPWR VGND sg13g2_decap_8
XFILLER_71_595 VPWR VGND sg13g2_fill_2
XFILLER_16_489 VPWR VGND sg13g2_fill_1
XFILLER_12_640 VPWR VGND sg13g2_decap_4
XFILLER_31_437 VPWR VGND sg13g2_decap_8
XFILLER_8_600 VPWR VGND sg13g2_decap_8
XFILLER_12_651 VPWR VGND sg13g2_decap_4
XFILLER_7_165 VPWR VGND sg13g2_decap_8
XFILLER_7_143 VPWR VGND sg13g2_decap_4
XFILLER_113_704 VPWR VGND sg13g2_decap_8
XFILLER_98_50 VPWR VGND sg13g2_fill_2
X_9601__2789 _9601_/RESET_B VPWR VGND sg13g2_tiehi
XFILLER_79_640 VPWR VGND sg13g2_decap_4
XFILLER_94_610 VPWR VGND sg13g2_decap_4
XFILLER_121_792 VPWR VGND sg13g2_fill_1
XFILLER_39_548 VPWR VGND sg13g2_fill_2
XFILLER_93_142 VPWR VGND sg13g2_decap_4
X_6940_ _9632_/D _5423_/B _6931_/Y _6939_/X VPWR VGND sg13g2_a21o_1
XFILLER_26_209 VPWR VGND sg13g2_decap_4
XFILLER_93_175 VPWR VGND sg13g2_decap_8
X_6871_ _6871_/X _8909_/Q _8941_/Q _6877_/S VPWR VGND sg13g2_mux2_1
XFILLER_34_242 VPWR VGND sg13g2_fill_1
X_5822_ _5823_/A _9304_/Q _8585_/A2 _8585_/B1 _9501_/Q VPWR VGND sg13g2_a22oi_1
X_9590_ _9590_/Q _9620_/CLK _9590_/D _9590_/RESET_B VPWR VGND sg13g2_dfrbpq_1
XFILLER_50_702 VPWR VGND sg13g2_decap_4
XFILLER_22_415 VPWR VGND sg13g2_fill_1
XFILLER_34_275 VPWR VGND sg13g2_decap_8
X_8610_ _8610_/Q _9689_/CLK _8610_/D fanout961/X VPWR VGND sg13g2_dfrbpq_1
X_5753_ _5753_/Y _9325_/Q _5765_/B VPWR VGND sg13g2_nand2b_1
X_8541_ _8541_/Y _8534_/A _8540_/Y _8544_/B VPWR VGND sg13g2_a21oi_1
X_4704_ _4705_/B _9670_/Q _4708_/A _9672_/Q VPWR VGND sg13g2_a21oi_1
X_5684_ _8595_/D _5684_/A VPWR VGND sg13g2_inv_1
X_8472_ _8472_/Y _8486_/A _9241_/Q _8492_/C VPWR VGND sg13g2_nand3_1
X_4635_ _4635_/Y _9460_/Q _9459_/Q VPWR VGND sg13g2_nand2b_1
Xplace2000 _5373_/B _5836_/C VPWR VGND sg13g2_buf_1
Xplace2011 _5467_/B2 _5469_/B2 VPWR VGND sg13g2_buf_1
X_7423_ _7424_/D _9154_/Q _7491_/B VPWR VGND sg13g2_nor2_1
Xplace2044 _5980_/A2 _5781_/Y VPWR VGND sg13g2_buf_1
X_4566_ _4567_/A _9654_/Q _9655_/Q VPWR VGND sg13g2_nor2_1
Xplace2022 _6840_/S _6813_/S VPWR VGND sg13g2_buf_1
Xplace2055 _5523_/B1 _5500_/Y VPWR VGND sg13g2_buf_1
X_7354_ _7354_/Y _7348_/Y _7353_/Y _7571_/B1 VPWR VGND sg13g2_o21ai_1
Xplace2033 _6399_/B _6410_/C VPWR VGND sg13g2_buf_1
XFILLER_116_553 VPWR VGND sg13g2_fill_2
Xclkbuf_leaf_8_jtag_tck_i_regs _9649_/CLK clkbuf_leaf_9_jtag_tck_i_regs/A VPWR VGND
+ sg13g2_buf_16
Xplace2088 _5769_/B _5739_/A VPWR VGND sg13g2_buf_1
Xplace2066 _8344_/A1 _7028_/D VPWR VGND sg13g2_buf_1
X_6305_ _9371_/D _6301_/Y _6303_/Y _6304_/Y VPWR VGND sg13g2_a21oi_1
Xplace2077 _8054_/A1 _5343_/Y VPWR VGND sg13g2_buf_1
X_7285_ _7286_/D _9275_/Q _5785_/C _7826_/A2 _9307_/Q _7269_/X VPWR VGND sg13g2_a221oi_1
Xplace2099 _7291_/B _7411_/B VPWR VGND sg13g2_buf_1
X_9024_ _9024_/Q _9183_/CLK _9024_/D place2469/X VPWR VGND sg13g2_dfrbpq_1
X_4497_ _4497_/Y _7296_/C _7723_/C VPWR VGND sg13g2_nand2b_1
XFILLER_103_247 VPWR VGND sg13g2_fill_2
XFILLER_103_236 VPWR VGND sg13g2_decap_8
X_6236_ _6238_/B _6451_/A _6124_/X _6270_/C VPWR VGND sg13g2_o21ai_1
XFILLER_112_770 VPWR VGND sg13g2_fill_2
X_6167_ _9354_/D _6165_/Y _6056_/Y _6166_/Y VPWR VGND sg13g2_a21oi_1
X_5118_ _5120_/A _5118_/A _5118_/B VPWR VGND sg13g2_nor2_1
XFILLER_57_312 VPWR VGND sg13g2_decap_8
X_6098_ _6369_/B _6322_/B _6247_/C VPWR VGND sg13g2_nand2_1
X_5049_ _5049_/Y _5055_/A _5084_/A _5085_/D VPWR VGND sg13g2_nor3_1
XFILLER_84_197 VPWR VGND sg13g2_decap_8
XFILLER_38_581 VPWR VGND sg13g2_fill_1
X_8808_ _8808_/Q _9304_/CLK _8808_/D place2415/X VPWR VGND sg13g2_dfrbpq_1
XFILLER_53_584 VPWR VGND sg13g2_decap_8
XFILLER_80_381 VPWR VGND sg13g2_decap_8
XFILLER_9_408 VPWR VGND sg13g2_fill_1
XFILLER_25_297 VPWR VGND sg13g2_fill_2
X_8739_ _8739_/Q _9672_/CLK _8739_/D place2441/X VPWR VGND sg13g2_dfrbpq_1
XFILLER_5_614 VPWR VGND sg13g2_decap_4
XFILLER_111_2 VPWR VGND sg13g2_fill_1
XFILLER_107_564 VPWR VGND sg13g2_decap_8
XFILLER_4_28 VPWR VGND sg13g2_decap_8
XFILLER_0_330 VPWR VGND sg13g2_fill_2
XFILLER_76_621 VPWR VGND sg13g2_decap_8
XFILLER_91_602 VPWR VGND sg13g2_fill_1
XFILLER_76_676 VPWR VGND sg13g2_fill_2
XFILLER_75_153 VPWR VGND sg13g2_fill_2
XFILLER_63_304 VPWR VGND sg13g2_decap_8
XFILLER_17_732 VPWR VGND sg13g2_decap_8
XFILLER_29_570 VPWR VGND sg13g2_fill_2
XFILLER_91_657 VPWR VGND sg13g2_decap_8
XFILLER_8_452 VPWR VGND sg13g2_decap_8
XFILLER_69_4 VPWR VGND sg13g2_fill_1
XFILLER_8_496 VPWR VGND sg13g2_fill_2
X_4420_ _6262_/C _9249_/Q _9250_/Q _9251_/Q VPWR VGND sg13g2_a21oi_1
X_4351_ _4506_/C _9652_/Q _4347_/Y _4350_/Y VPWR VGND sg13g2_o21ai_1
XFILLER_99_735 VPWR VGND sg13g2_decap_8
X_7070_ _8843_/D _7069_/Y _8843_/Q _7085_/S VPWR VGND sg13g2_mux2_1
XFILLER_100_217 VPWR VGND sg13g2_fill_2
X_6021_ _6021_/X _6015_/Y _6019_/Y _6014_/Y VPWR VGND sg13g2_a21o_1
XFILLER_104_18 VPWR VGND sg13g2_fill_1
XFILLER_67_665 VPWR VGND sg13g2_decap_8
XFILLER_12_0 VPWR VGND sg13g2_fill_2
XFILLER_27_507 VPWR VGND sg13g2_decap_4
XFILLER_94_484 VPWR VGND sg13g2_fill_1
XFILLER_82_613 VPWR VGND sg13g2_decap_4
X_7972_ _8996_/D _5350_/C _7975_/A _7971_/Y VPWR VGND sg13g2_o21ai_1
XFILLER_82_657 VPWR VGND sg13g2_fill_2
XFILLER_54_359 VPWR VGND sg13g2_decap_8
XFILLER_54_348 VPWR VGND sg13g2_fill_1
X_6923_ _9626_/D _9626_/Q _6915_/B _6922_/X VPWR VGND sg13g2_a21o_1
XFILLER_120_28 VPWR VGND sg13g2_decap_8
X_9642_ _9642_/Q _9645_/CLK _9642_/D fanout976/X VPWR VGND sg13g2_dfrbpq_1
X_6854_ _9593_/D _6853_/X _9593_/Q _6906_/S VPWR VGND sg13g2_mux2_1
XFILLER_50_521 VPWR VGND sg13g2_decap_8
XFILLER_35_595 VPWR VGND sg13g2_decap_8
X_5805_ _9295_/D _5805_/A VPWR VGND sg13g2_inv_1
X_9573_ _9573_/Q _9588_/CLK _9573_/D _9573_/RESET_B VPWR VGND sg13g2_dfrbpq_1
X_6785_ _9544_/D _9544_/Q _6566_/D _6785_/S VPWR VGND sg13g2_mux2_1
X_8524_ _8525_/A _9262_/Q _8516_/X _8519_/Y _9487_/Q VPWR VGND sg13g2_a22oi_1
X_5736_ _5736_/Y _5736_/A _9320_/Q VPWR VGND sg13g2_nand2_1
X_8455_ _9232_/D _8474_/A _5346_/C _8454_/Y VPWR VGND sg13g2_o21ai_1
XFILLER_13_59 VPWR VGND sg13g2_fill_2
X_5667_ _5668_/A _8605_/Q _5677_/A2 _5677_/B1 _5667_/B2 VPWR VGND sg13g2_a22oi_1
X_4618_ _4621_/B _9688_/Q _4618_/B VPWR VGND sg13g2_nor2_1
X_7406_ _7407_/C _7410_/A _8998_/Q _7832_/C VPWR VGND sg13g2_nor3_1
XFILLER_123_309 VPWR VGND sg13g2_decap_8
X_8386_ _9193_/D _5361_/C _8403_/A _8385_/Y VPWR VGND sg13g2_o21ai_1
X_5598_ _5598_/Y _9452_/Q _5600_/B _5601_/B1 _8654_/Q VPWR VGND sg13g2_a22oi_1
XFILLER_116_383 VPWR VGND sg13g2_fill_1
X_4549_ _7461_/C _5383_/B _7701_/C VPWR VGND sg13g2_nor2_1
X_7337_ _7340_/C _7831_/C _7650_/C _8837_/Q VPWR VGND sg13g2_nand3_1
X_7268_ _8896_/D _8896_/Q _7267_/Y _7830_/S VPWR VGND sg13g2_mux2_1
X_6219_ _6219_/X _8978_/Q _9040_/Q _9102_/Q _9164_/Q _6480_/S0 _6480_/S1 VPWR VGND
+ sg13g2_mux4_1
XFILLER_89_289 VPWR VGND sg13g2_decap_8
X_9007_ _9007_/Q _9199_/CLK _9007_/D place2424/X VPWR VGND sg13g2_dfrbpq_1
Xfanout932 place2507/A rst_ni VPWR VGND sg13g2_buf_1
Xfanout943 fanout943/X fanout945/X VPWR VGND sg13g2_buf_1
Xfanout976 fanout976/X fanout977/X VPWR VGND sg13g2_buf_1
Xfanout965 fanout965/X fanout967/X VPWR VGND sg13g2_buf_1
X_7199_ _7199_/Y _8487_/A2 _7222_/A2 _7198_/Y VPWR VGND sg13g2_o21ai_1
Xfanout954 fanout954/X fanout956/X VPWR VGND sg13g2_buf_1
Xfanout987 _4743_/A _4744_/B1 VPWR VGND sg13g2_buf_1
XFILLER_100_784 VPWR VGND sg13g2_fill_2
XFILLER_73_635 VPWR VGND sg13g2_fill_1
XFILLER_57_186 VPWR VGND sg13g2_fill_2
XFILLER_57_175 VPWR VGND sg13g2_decap_8
XFILLER_54_11 VPWR VGND sg13g2_decap_8
XFILLER_26_540 VPWR VGND sg13g2_decap_4
XFILLER_26_551 VPWR VGND sg13g2_decap_8
XFILLER_13_212 VPWR VGND sg13g2_fill_2
XFILLER_26_584 VPWR VGND sg13g2_fill_1
XFILLER_9_216 VPWR VGND sg13g2_fill_1
XFILLER_41_554 VPWR VGND sg13g2_fill_1
Xclkload19 clkload19/Y _9675_/CLK VPWR VGND sg13g2_inv_2
XFILLER_5_444 VPWR VGND sg13g2_decap_4
XFILLER_107_372 VPWR VGND sg13g2_decap_4
XFILLER_5_499 VPWR VGND sg13g2_decap_8
XFILLER_96_716 VPWR VGND sg13g2_fill_2
XFILLER_110_526 VPWR VGND sg13g2_decap_8
XFILLER_0_160 VPWR VGND sg13g2_fill_2
XFILLER_76_473 VPWR VGND sg13g2_decap_8
Xclkbuf_3_5__f_clk_i clkload2/A clkbuf_0_clk_i/X VPWR VGND sg13g2_buf_8
XFILLER_64_668 VPWR VGND sg13g2_decap_8
XFILLER_52_808 VPWR VGND sg13g2_fill_1
XFILLER_36_337 VPWR VGND sg13g2_decap_8
XFILLER_91_476 VPWR VGND sg13g2_fill_2
XFILLER_51_307 VPWR VGND sg13g2_fill_1
X_6570_ _9422_/D _6568_/Y _6569_/Y _6565_/Y VPWR VGND sg13g2_o21ai_1
X_5521_ _8628_/D _5520_/Y _5519_/Y _6546_/D VPWR VGND sg13g2_a21oi_1
XFILLER_117_125 VPWR VGND sg13g2_fill_2
X_8240_ _9120_/D _8244_/A1 _7902_/Y _8239_/Y VPWR VGND sg13g2_o21ai_1
XFILLER_105_309 VPWR VGND sg13g2_decap_8
X_5452_ _8684_/D _5452_/A _5454_/B_N VPWR VGND sg13g2_nor2b_1
XFILLER_99_521 VPWR VGND sg13g2_decap_4
X_5383_ _5383_/Y _7704_/A _5383_/B _7701_/C _7775_/D VPWR VGND sg13g2_nor4_1
X_8171_ _8171_/Y _8171_/A _8197_/B VPWR VGND sg13g2_nand2_1
X_4403_ _4404_/A _5435_/A2 _8669_/Q _4403_/B1 _5469_/B2 VPWR VGND sg13g2_a22oi_1
X_4334_ _4334_/Y _9650_/Q VPWR VGND sg13g2_inv_1
Xoutput2678 master_addr_o[25] _9883_/X VPWR VGND sg13g2_buf_1
Xoutput2667 master_addr_o[15] _9873_/X VPWR VGND sg13g2_buf_1
Xoutput2689 master_addr_o[6] _9864_/X VPWR VGND sg13g2_buf_1
X_7122_ _8860_/D _7121_/Y _8860_/Q _7131_/S VPWR VGND sg13g2_mux2_1
X_7053_ _7053_/Y _7056_/A _8838_/Q VPWR VGND sg13g2_nand2_1
X_6004_ _6004_/Y _6004_/A _6004_/B _6004_/C VPWR VGND sg13g2_nand3_1
XFILLER_99_598 VPWR VGND sg13g2_decap_8
XFILLER_101_559 VPWR VGND sg13g2_fill_1
XFILLER_55_613 VPWR VGND sg13g2_decap_8
XFILLER_54_145 VPWR VGND sg13g2_decap_8
XFILLER_54_123 VPWR VGND sg13g2_fill_2
X_7955_ _8988_/D _5373_/C _7924_/A _7953_/Y VPWR VGND sg13g2_o21ai_1
X_6906_ _9619_/D _6905_/X _9619_/Q _6906_/S VPWR VGND sg13g2_mux2_1
X_7886_ _7886_/Y _7899_/A _8959_/Q _8353_/C VPWR VGND sg13g2_nand3_1
XFILLER_23_532 VPWR VGND sg13g2_fill_2
X_6837_ _9585_/D _9618_/Q _9585_/Q _6839_/S VPWR VGND sg13g2_mux2_1
X_9625_ _9625_/Q _9701_/CLK _9625_/D fanout951/X VPWR VGND sg13g2_dfrbpq_1
X_9556_ _9556_/Q _9645_/CLK _9556_/D _9556_/RESET_B VPWR VGND sg13g2_dfrbpq_1
X_6768_ _9527_/D _9527_/Q _9437_/Q _6786_/S VPWR VGND sg13g2_mux2_1
X_8507_ _9256_/D _8744_/Q _8507_/B _8507_/C VPWR VGND sg13g2_nor3_1
X_9487_ _9487_/Q _9621_/CLK _9487_/D _9487_/RESET_B VPWR VGND sg13g2_dfrbpq_1
XFILLER_108_114 VPWR VGND sg13g2_fill_1
X_5719_ _5719_/Y _5762_/A1 _5740_/A2 _5717_/Y _5718_/Y VPWR VGND sg13g2_a22oi_1
X_6699_ _9467_/D _9508_/Q _9467_/Q _6702_/S VPWR VGND sg13g2_mux2_1
X_8438_ _8438_/Y _8448_/A _9224_/Q _8448_/C VPWR VGND sg13g2_nand3_1
X_8369_ _8369_/Y _8375_/A _9185_/Q _8375_/C VPWR VGND sg13g2_nand3_1
Xclkbuf_leaf_9_clk_i _9504_/CLK clkbuf_leaf_9_clk_i/A VPWR VGND sg13g2_buf_16
XFILLER_77_215 VPWR VGND sg13g2_decap_8
XFILLER_86_760 VPWR VGND sg13g2_decap_8
Xfanout773 _7168_/D slave_be_i[1] VPWR VGND sg13g2_buf_1
XFILLER_100_570 VPWR VGND sg13g2_fill_1
XFILLER_18_359 VPWR VGND sg13g2_fill_2
XFILLER_45_145 VPWR VGND sg13g2_decap_4
XFILLER_61_638 VPWR VGND sg13g2_fill_2
XFILLER_60_126 VPWR VGND sg13g2_fill_2
XFILLER_14_80 VPWR VGND sg13g2_decap_4
Xplace1909 _8056_/C _8095_/C VPWR VGND sg13g2_buf_1
XFILLER_53_7 VPWR VGND sg13g2_decap_4
XFILLER_123_673 VPWR VGND sg13g2_decap_8
XFILLER_69_716 VPWR VGND sg13g2_fill_1
XFILLER_68_248 VPWR VGND sg13g2_fill_2
XFILLER_49_451 VPWR VGND sg13g2_decap_8
XFILLER_25_808 VPWR VGND sg13g2_fill_1
XFILLER_36_112 VPWR VGND sg13g2_decap_4
XFILLER_92_774 VPWR VGND sg13g2_decap_8
XFILLER_24_307 VPWR VGND sg13g2_decap_4
X_7740_ _7744_/B _7747_/A _7803_/B _8984_/Q VPWR VGND sg13g2_nor3_1
X_4952_ _4952_/Y _4783_/B _4947_/Y _4951_/Y VPWR VGND sg13g2_o21ai_1
X_4883_ _4887_/A _4883_/A _9357_/Q VPWR VGND sg13g2_nor2b_1
X_7671_ _7672_/C _7718_/A _7839_/B _9104_/Q VPWR VGND sg13g2_nor3_1
X_6622_ _6622_/X _6661_/A _9572_/Q _6622_/C VPWR VGND sg13g2_or3_1
X_9410_ _9410_/Q _9410_/CLK _9410_/D place2404/X VPWR VGND sg13g2_dfrbpq_1
X_9341_ _9341_/Q _9414_/CLK _9341_/D place2500/X VPWR VGND sg13g2_dfrbpq_1
X_6553_ _9418_/D _8659_/Q _6544_/Y _6552_/X VPWR VGND sg13g2_a21o_1
X_9272_ _9272_/Q _9304_/CLK _9272_/D place2407/X VPWR VGND sg13g2_dfrbpq_1
X_6484_ _9402_/D _6483_/Y _9402_/Q _6484_/S VPWR VGND sg13g2_mux2_1
XFILLER_9_591 VPWR VGND sg13g2_decap_4
X_5504_ _5506_/A _6545_/B _5629_/A _8623_/Q VPWR VGND sg13g2_a21oi_1
X_5435_ _5436_/A _5435_/A1 _5435_/A2 _5434_/Y VPWR VGND sg13g2_a21oi_1
X_8223_ _8223_/Y _9112_/Q _8225_/B VPWR VGND sg13g2_nand2_1
XFILLER_10_49 VPWR VGND sg13g2_decap_8
X_8154_ _9077_/D _8160_/A1 _8089_/Y _8153_/Y VPWR VGND sg13g2_o21ai_1
X_5366_ _8806_/D _5366_/A _5366_/B _5366_/C _5366_/D VPWR VGND sg13g2_nor4_1
X_4317_ _4344_/B _9658_/Q VPWR VGND sg13g2_inv_1
X_5297_ _5297_/Y _5319_/A _9496_/Q VPWR VGND sg13g2_nand2_1
X_8085_ _8085_/Y _9045_/Q _8101_/B VPWR VGND sg13g2_nand2_1
X_7105_ _7105_/Y _7207_/A _7207_/B _7105_/C VPWR VGND sg13g2_nand3_1
XFILLER_113_194 VPWR VGND sg13g2_fill_2
XFILLER_19_36 VPWR VGND sg13g2_fill_1
X_7036_ _7036_/X _7236_/C _7036_/B _7036_/C _7132_/A VPWR VGND sg13g2_and4_1
XFILLER_74_207 VPWR VGND sg13g2_decap_8
XFILLER_28_657 VPWR VGND sg13g2_decap_8
X_9614__2776 _9614_/RESET_B VPWR VGND sg13g2_tiehi
XFILLER_83_774 VPWR VGND sg13g2_fill_1
X_8987_ _8987_/Q _9199_/CLK _8987_/D place2424/X VPWR VGND sg13g2_dfrbpq_1
X_7938_ _7938_/Y _7948_/A _8981_/Q _8401_/C VPWR VGND sg13g2_nand3_1
XFILLER_15_318 VPWR VGND sg13g2_decap_4
XFILLER_43_627 VPWR VGND sg13g2_fill_2
X_9608_ _9608_/Q _9615_/CLK _9608_/D _9608_/RESET_B VPWR VGND sg13g2_dfrbpq_1
X_7869_ _8943_/D _8943_/Q _7555_/Y _7883_/S VPWR VGND sg13g2_mux2_1
XFILLER_51_45 VPWR VGND sg13g2_fill_1
XFILLER_11_546 VPWR VGND sg13g2_fill_2
X_9539_ _9539_/Q _9567_/CLK _9539_/D _9539_/RESET_B VPWR VGND sg13g2_dfrbpq_1
XFILLER_3_701 VPWR VGND sg13g2_decap_8
XFILLER_104_172 VPWR VGND sg13g2_decap_4
XFILLER_104_161 VPWR VGND sg13g2_fill_1
XFILLER_2_277 VPWR VGND sg13g2_decap_8
XFILLER_104_194 VPWR VGND sg13g2_fill_2
XFILLER_78_579 VPWR VGND sg13g2_fill_2
XFILLER_120_698 VPWR VGND sg13g2_decap_8
XFILLER_93_538 VPWR VGND sg13g2_decap_4
XFILLER_74_774 VPWR VGND sg13g2_fill_2
XFILLER_61_424 VPWR VGND sg13g2_decap_4
XFILLER_61_446 VPWR VGND sg13g2_fill_1
XFILLER_25_90 VPWR VGND sg13g2_decap_8
XFILLER_30_800 VPWR VGND sg13g2_fill_1
XFILLER_42_671 VPWR VGND sg13g2_fill_2
Xplace2418 place2418/X place2419/X VPWR VGND sg13g2_buf_1
Xplace2407 place2407/X place2408/X VPWR VGND sg13g2_buf_1
Xplace2429 place2429/X place2430/X VPWR VGND sg13g2_buf_1
X_5220_ _5357_/C _8448_/C _9484_/Q VPWR VGND sg13g2_nand2_1
Xhold3109 _5609_/A _9417_/Q VPWR VGND sg13g2_dlygate4sd3_1
XFILLER_123_470 VPWR VGND sg13g2_fill_1
X_5151_ _5192_/B _5151_/A _5151_/B VPWR VGND sg13g2_nand2_1
XFILLER_110_120 VPWR VGND sg13g2_fill_1
X_5082_ _5083_/C _5123_/A _9259_/Q _9262_/Q VPWR VGND sg13g2_and3_1
XFILLER_57_708 VPWR VGND sg13g2_fill_2
X_8910_ _8910_/Q _9603_/CLK _8910_/D place2431/X VPWR VGND sg13g2_dfrbpq_1
XFILLER_84_516 VPWR VGND sg13g2_decap_4
XFILLER_49_270 VPWR VGND sg13g2_fill_2
XFILLER_80_711 VPWR VGND sg13g2_fill_1
X_8841_ _8841_/Q _9251_/CLK _8841_/D place2479/X VPWR VGND sg13g2_dfrbpq_1
XFILLER_92_571 VPWR VGND sg13g2_decap_4
X_8772_ _9878_/A _9260_/CLK _8772_/D place2391/X VPWR VGND sg13g2_dfrbpq_1
XFILLER_64_273 VPWR VGND sg13g2_fill_2
XFILLER_24_126 VPWR VGND sg13g2_decap_8
XFILLER_25_649 VPWR VGND sg13g2_fill_1
X_5984_ _5984_/Y _5123_/A _5368_/C _5983_/Y VPWR VGND sg13g2_o21ai_1
XFILLER_52_457 VPWR VGND sg13g2_decap_8
X_7723_ _7727_/A _7839_/C _9138_/Q _7723_/C VPWR VGND sg13g2_nor3_1
XFILLER_24_137 VPWR VGND sg13g2_fill_2
X_4935_ _4935_/Y _4935_/A _4935_/B _4935_/C VPWR VGND sg13g2_nand3_1
X_7654_ _7656_/C _8804_/Q _7660_/A2 _7809_/B1 _7654_/B2 VPWR VGND sg13g2_a22oi_1
X_4866_ _4868_/A _5012_/A _4778_/Y _4833_/A _4939_/A2 _4772_/A VPWR VGND sg13g2_a221oi_1
X_6605_ _9433_/D _6663_/A1 _6604_/Y _6603_/Y VPWR VGND sg13g2_o21ai_1
X_7585_ _7586_/D _9193_/Q _7627_/B _7801_/A VPWR VGND sg13g2_o21ai_1
X_4797_ _4797_/Y _4855_/A _9348_/Q VPWR VGND sg13g2_nor2b_1
X_9324_ _9324_/Q _9410_/CLK _9324_/D place2397/X VPWR VGND sg13g2_dfrbpq_1
X_6536_ _9411_/D _9411_/Q _6536_/A1 _6539_/S VPWR VGND sg13g2_mux2_1
X_9255_ _9255_/Q _9675_/CLK _9255_/D place2444/X VPWR VGND sg13g2_dfrbpq_1
X_6467_ _6467_/Y _6465_/Y _6466_/Y _6455_/A VPWR VGND sg13g2_a21oi_1
X_8206_ _9103_/D _8226_/A1 _8074_/Y _8205_/Y VPWR VGND sg13g2_o21ai_1
X_9186_ _9186_/Q clkload4/A _9186_/D place2482/X VPWR VGND sg13g2_dfrbpq_1
X_6398_ _6398_/Y _6399_/A _6399_/B _6399_/D VPWR VGND sg13g2_nor3_1
X_5418_ _5418_/Y _9627_/Q _4382_/Y _5416_/B VPWR VGND sg13g2_a21oi_1
XFILLER_102_621 VPWR VGND sg13g2_fill_2
X_8137_ _8137_/Y _8137_/A _8159_/B VPWR VGND sg13g2_nand2_1
XFILLER_87_321 VPWR VGND sg13g2_fill_1
X_5349_ _8789_/D _5375_/A _5373_/B _5349_/C _5373_/D VPWR VGND sg13g2_nor4_1
XFILLER_0_737 VPWR VGND sg13g2_decap_4
Xhold2931 _8700_/D _8699_/Q VPWR VGND sg13g2_dlygate4sd3_1
Xhold2920 _8699_/D _8698_/Q VPWR VGND sg13g2_dlygate4sd3_1
Xhold2964 _4483_/A1 _9651_/Q VPWR VGND sg13g2_dlygate4sd3_1
XFILLER_87_376 VPWR VGND sg13g2_fill_2
XFILLER_87_365 VPWR VGND sg13g2_fill_1
Xhold2942 hold2942/X _8731_/Q VPWR VGND sg13g2_dlygate4sd3_1
Xhold2975 _6470_/B1 _9400_/Q VPWR VGND sg13g2_dlygate4sd3_1
X_8068_ _8068_/Y _8086_/A _9489_/Q _8095_/C _8068_/D VPWR VGND sg13g2_nand4_1
Xhold2953 _4581_/A _9699_/Q VPWR VGND sg13g2_dlygate4sd3_1
X_7019_ _7019_/Y _7019_/A _8159_/B VPWR VGND sg13g2_nand2_1
Xhold2986 _4568_/B _9668_/Q VPWR VGND sg13g2_dlygate4sd3_1
Xhold2997 _6335_/B1 _9375_/Q VPWR VGND sg13g2_dlygate4sd3_1
XFILLER_16_605 VPWR VGND sg13g2_decap_4
XFILLER_46_45 VPWR VGND sg13g2_decap_4
Xclkbuf_leaf_12_clk_i _9611_/CLK clkload3/A VPWR VGND sg13g2_buf_16
XFILLER_15_104 VPWR VGND sg13g2_decap_8
XFILLER_70_287 VPWR VGND sg13g2_fill_1
XFILLER_31_619 VPWR VGND sg13g2_decap_4
XFILLER_11_343 VPWR VGND sg13g2_decap_4
Xclkbuf_leaf_27_clk_i _9242_/CLK clkbuf_3_2__f_clk_i/X VPWR VGND sg13g2_buf_16
XFILLER_7_28 VPWR VGND sg13g2_decap_8
XFILLER_109_253 VPWR VGND sg13g2_fill_2
XFILLER_98_608 VPWR VGND sg13g2_fill_2
XFILLER_105_492 VPWR VGND sg13g2_decap_4
XFILLER_94_803 VPWR VGND sg13g2_fill_2
XFILLER_78_332 VPWR VGND sg13g2_fill_1
XFILLER_120_462 VPWR VGND sg13g2_decap_8
XFILLER_78_365 VPWR VGND sg13g2_fill_2
XFILLER_38_207 VPWR VGND sg13g2_decap_8
XFILLER_66_538 VPWR VGND sg13g2_decap_8
XFILLER_34_446 VPWR VGND sg13g2_decap_8
XFILLER_15_660 VPWR VGND sg13g2_fill_1
X_4720_ _4721_/B _9682_/Q _6956_/S VPWR VGND sg13g2_nor2_1
XFILLER_14_181 VPWR VGND sg13g2_decap_8
XFILLER_15_693 VPWR VGND sg13g2_decap_4
X_4651_ _6682_/S _4652_/A _4651_/B _4651_/C VPWR VGND sg13g2_nor3_1
Xplace2204 _6937_/B _6737_/C VPWR VGND sg13g2_buf_1
Xplace2226 _7299_/A _7822_/A VPWR VGND sg13g2_buf_1
Xplace2237 _7351_/C _7333_/A VPWR VGND sg13g2_buf_1
X_4582_ _9699_/D _4590_/C _4582_/B VPWR VGND sg13g2_nor2_1
X_7370_ _7371_/D _9027_/Q _7411_/B _7369_/Y VPWR VGND sg13g2_o21ai_1
Xplace2215 _6915_/A _9623_/Q VPWR VGND sg13g2_buf_1
XFILLER_116_757 VPWR VGND sg13g2_fill_2
Xplace2259 _5383_/B _7644_/A VPWR VGND sg13g2_buf_1
Xplace2248 _7747_/A _7718_/A VPWR VGND sg13g2_buf_1
X_6321_ _9373_/D _6317_/Y _6319_/Y _6320_/Y VPWR VGND sg13g2_a21oi_1
X_9040_ _9040_/Q _9611_/CLK _9040_/D place2411/X VPWR VGND sg13g2_dfrbpq_1
X_6252_ _6252_/Y _6171_/Y _6249_/Y _6251_/Y VPWR VGND sg13g2_o21ai_1
XFILLER_42_0 VPWR VGND sg13g2_decap_8
X_6183_ _6183_/Y _9157_/Q _6173_/A _6077_/A _9033_/Q VPWR VGND sg13g2_a22oi_1
X_5203_ _5354_/C _5203_/A _9481_/Q VPWR VGND sg13g2_nand2_1
XFILLER_97_652 VPWR VGND sg13g2_decap_8
X_5134_ _5134_/Y _5134_/A _5134_/B _5134_/C VPWR VGND sg13g2_nand3_1
XFILLER_84_302 VPWR VGND sg13g2_fill_2
XFILLER_123_28 VPWR VGND sg13g2_decap_8
X_5065_ _5065_/Y _5132_/B _5085_/C _5065_/C _5065_/D VPWR VGND sg13g2_nor4_1
XFILLER_69_398 VPWR VGND sg13g2_fill_2
X_9873_ _9873_/X _9873_/A VPWR VGND sg13g2_buf_1
X_8824_ _8824_/Q _9504_/CLK _8824_/D place2431/X VPWR VGND sg13g2_dfrbpq_1
X_9523__2857 _9523_/RESET_B VPWR VGND sg13g2_tiehi
XFILLER_80_530 VPWR VGND sg13g2_decap_8
XFILLER_13_608 VPWR VGND sg13g2_fill_1
XFILLER_25_457 VPWR VGND sg13g2_decap_4
X_5967_ _9324_/D _5978_/B _5965_/Y _5966_/Y VPWR VGND sg13g2_o21ai_1
X_8755_ _9861_/A _9252_/CLK _8755_/D place2391/X VPWR VGND sg13g2_dfrbpq_1
XFILLER_53_777 VPWR VGND sg13g2_fill_1
X_7706_ _7709_/B _9199_/Q _7724_/B VPWR VGND sg13g2_nor2_1
XFILLER_52_298 VPWR VGND sg13g2_fill_1
X_4918_ _4918_/Y _4994_/A _9361_/Q VPWR VGND sg13g2_nand2b_1
XFILLER_12_129 VPWR VGND sg13g2_decap_8
X_8686_ _8686_/Q _9630_/CLK _8686_/D fanout945/X VPWR VGND sg13g2_dfrbpq_1
X_5898_ _5898_/Y _5930_/A1 _5930_/A2 _5897_/Y VPWR VGND sg13g2_a21oi_1
X_7637_ _7637_/Y _7811_/A _7811_/B _7811_/C _7637_/D VPWR VGND sg13g2_nor4_1
XFILLER_120_7 VPWR VGND sg13g2_decap_8
X_4849_ _4849_/Y _4750_/A _4833_/A _4848_/Y _4782_/D _4772_/A VPWR VGND sg13g2_a221oi_1
X_7568_ _7570_/C _9037_/Q _7838_/B VPWR VGND sg13g2_nor2_1
X_9307_ _9307_/Q _9410_/CLK _9307_/D place2406/X VPWR VGND sg13g2_dfrbpq_1
X_6519_ _6519_/X _6519_/A _6519_/B _6519_/C _6519_/D VPWR VGND sg13g2_or4_1
X_7499_ _7499_/Y _7484_/Y _7498_/Y _4541_/Y VPWR VGND sg13g2_o21ai_1
Xdelaybuf_1_clk_jtg delaybuf_2_clk_jtg/A delaybuf_1_clk_jtg/A VPWR VGND sg13g2_buf_8
X_9238_ _9238_/Q clkload4/A _9238_/D place2480/X VPWR VGND sg13g2_dfrbpq_1
XFILLER_88_641 VPWR VGND sg13g2_fill_1
X_9169_ _9169_/Q clkload6/A _9169_/D place2434/X VPWR VGND sg13g2_dfrbpq_1
XFILLER_88_696 VPWR VGND sg13g2_decap_8
XFILLER_75_335 VPWR VGND sg13g2_decap_8
XFILLER_29_730 VPWR VGND sg13g2_decap_8
XFILLER_57_99 VPWR VGND sg13g2_fill_2
XFILLER_113_50 VPWR VGND sg13g2_decap_4
XFILLER_90_338 VPWR VGND sg13g2_decap_8
XFILLER_56_560 VPWR VGND sg13g2_decap_8
XFILLER_16_435 VPWR VGND sg13g2_decap_8
XFILLER_44_744 VPWR VGND sg13g2_decap_8
XFILLER_31_416 VPWR VGND sg13g2_fill_1
XFILLER_44_788 VPWR VGND sg13g2_decap_4
XFILLER_8_634 VPWR VGND sg13g2_decap_8
XFILLER_22_80 VPWR VGND sg13g2_decap_8
XFILLER_98_40 VPWR VGND sg13g2_fill_1
XFILLER_113_749 VPWR VGND sg13g2_decap_8
XFILLER_112_204 VPWR VGND sg13g2_decap_4
XFILLER_98_438 VPWR VGND sg13g2_decap_8
XFILLER_98_416 VPWR VGND sg13g2_decap_8
X_9573__2817 _9573_/RESET_B VPWR VGND sg13g2_tiehi
XFILLER_3_394 VPWR VGND sg13g2_fill_1
XFILLER_93_154 VPWR VGND sg13g2_decap_8
XFILLER_82_806 VPWR VGND sg13g2_fill_2
XFILLER_66_368 VPWR VGND sg13g2_decap_4
XFILLER_81_338 VPWR VGND sg13g2_fill_2
XFILLER_47_582 VPWR VGND sg13g2_decap_4
X_6870_ _9601_/D _6869_/X _9601_/Q _6900_/S VPWR VGND sg13g2_mux2_1
X_5821_ _9303_/D _5821_/A VPWR VGND sg13g2_inv_1
XFILLER_62_574 VPWR VGND sg13g2_fill_2
X_8540_ _8540_/Y _8540_/A _8540_/B VPWR VGND sg13g2_nand2_1
X_5752_ _5752_/Y _5763_/B1 _5750_/Y _5751_/Y VPWR VGND sg13g2_a21oi_1
XFILLER_22_427 VPWR VGND sg13g2_fill_1
X_4703_ _4703_/Y _8739_/Q _9670_/Q VPWR VGND sg13g2_nor2b_1
X_8471_ _9240_/D _8470_/A _5354_/C _8470_/Y VPWR VGND sg13g2_o21ai_1
X_5683_ _5684_/A _8596_/Q _5693_/A2 _5693_/B1 _5683_/B2 VPWR VGND sg13g2_a22oi_1
X_4634_ _8717_/D _4634_/A VPWR VGND sg13g2_inv_1
Xplace2001 _5836_/C _8563_/C VPWR VGND sg13g2_buf_1
Xplace2012 _5451_/B2 _5469_/B2 VPWR VGND sg13g2_buf_1
X_7422_ _7424_/B _7486_/A _7492_/B _9092_/Q VPWR VGND sg13g2_nor3_1
XFILLER_118_28 VPWR VGND sg13g2_fill_2
XFILLER_116_521 VPWR VGND sg13g2_fill_1
X_4565_ _4565_/Y _4565_/A hold3014/X VPWR VGND sg13g2_nor2b_1
Xplace2023 _6710_/S _6733_/S VPWR VGND sg13g2_buf_1
X_7353_ _7353_/Y _7389_/A _7353_/B _7353_/C _7353_/D VPWR VGND sg13g2_nor4_1
Xplace2034 _6229_/B _6332_/B VPWR VGND sg13g2_buf_1
Xplace2045 _5699_/B1 _5629_/Y VPWR VGND sg13g2_buf_1
XFILLER_116_565 VPWR VGND sg13g2_fill_2
Xplace2056 _5592_/A2 _5498_/X VPWR VGND sg13g2_buf_1
Xplace2078 _5716_/A _5736_/A VPWR VGND sg13g2_buf_1
Xplace2067 _7028_/D _5398_/D VPWR VGND sg13g2_buf_1
X_6304_ _6304_/Y _6312_/C _6312_/A _6304_/B1 VPWR VGND sg13g2_a21oi_1
XFILLER_116_587 VPWR VGND sg13g2_decap_8
Xplace2089 _5739_/A _5736_/A VPWR VGND sg13g2_buf_1
X_4496_ _7519_/C _5383_/B _5826_/A VPWR VGND sg13g2_nor2_1
X_9023_ _9023_/Q clkload5/A _9023_/D place2484/X VPWR VGND sg13g2_dfrbpq_1
X_7284_ _7286_/C _8834_/Q _7598_/A2 _7598_/B1 _8865_/Q _5412_/C VPWR VGND sg13g2_a221oi_1
XFILLER_89_449 VPWR VGND sg13g2_decap_8
X_6235_ _6238_/A _6234_/Y _6224_/A _9231_/Q VPWR VGND sg13g2_a21o_1
XFILLER_97_471 VPWR VGND sg13g2_decap_8
XFILLER_97_460 VPWR VGND sg13g2_decap_8
X_6166_ _6166_/Y _6379_/A1 _6379_/A2 _6166_/B1 VPWR VGND sg13g2_a21oi_1
X_5117_ _5117_/Y _5175_/B _5117_/B _5147_/D _5117_/D VPWR VGND sg13g2_nand4_1
XFILLER_69_184 VPWR VGND sg13g2_decap_8
X_6097_ _6322_/B _9231_/Q _9233_/Q _6097_/C _6097_/D VPWR VGND sg13g2_nand4_1
X_5048_ _5048_/Y _5055_/A _5057_/A _5098_/A _5048_/D VPWR VGND sg13g2_nor4_1
XFILLER_27_69 VPWR VGND sg13g2_fill_1
XFILLER_25_210 VPWR VGND sg13g2_decap_8
X_8807_ _8807_/Q _9219_/CLK _8807_/D place2409/X VPWR VGND sg13g2_dfrbpq_1
XFILLER_25_243 VPWR VGND sg13g2_decap_8
XFILLER_25_254 VPWR VGND sg13g2_fill_2
XFILLER_26_788 VPWR VGND sg13g2_fill_2
X_6999_ _6999_/Y _8821_/Q _7846_/A2 _7846_/B1 _6999_/B2 _6998_/Y VPWR VGND sg13g2_a221oi_1
X_8738_ _8738_/Q _9678_/CLK _8738_/D fanout965/X VPWR VGND sg13g2_dfrbpq_1
XFILLER_25_287 VPWR VGND sg13g2_fill_2
XFILLER_41_769 VPWR VGND sg13g2_decap_8
X_8669_ _8669_/Q _8678_/CLK _8669_/D fanout945/X VPWR VGND sg13g2_dfrbpq_1
XFILLER_108_61 VPWR VGND sg13g2_decap_4
XFILLER_107_598 VPWR VGND sg13g2_decap_8
XFILLER_4_169 VPWR VGND sg13g2_decap_8
XFILLER_76_655 VPWR VGND sg13g2_decap_8
XFILLER_48_346 VPWR VGND sg13g2_fill_1
XFILLER_91_625 VPWR VGND sg13g2_decap_8
XFILLER_84_53 VPWR VGND sg13g2_fill_1
XFILLER_84_42 VPWR VGND sg13g2_decap_8
XFILLER_76_699 VPWR VGND sg13g2_decap_8
XFILLER_63_349 VPWR VGND sg13g2_fill_2
XFILLER_17_744 VPWR VGND sg13g2_decap_8
XFILLER_17_755 VPWR VGND sg13g2_fill_2
XFILLER_90_179 VPWR VGND sg13g2_fill_1
XFILLER_44_563 VPWR VGND sg13g2_fill_2
XFILLER_44_574 VPWR VGND sg13g2_decap_8
XFILLER_71_382 VPWR VGND sg13g2_decap_8
XFILLER_31_224 VPWR VGND sg13g2_decap_4
XFILLER_31_235 VPWR VGND sg13g2_fill_1
XFILLER_32_736 VPWR VGND sg13g2_decap_8
XFILLER_32_747 VPWR VGND sg13g2_fill_1
XFILLER_31_268 VPWR VGND sg13g2_fill_2
XFILLER_12_482 VPWR VGND sg13g2_decap_8
XFILLER_12_460 VPWR VGND sg13g2_decap_8
XFILLER_8_431 VPWR VGND sg13g2_decap_8
XFILLER_117_307 VPWR VGND sg13g2_fill_2
XFILLER_12_493 VPWR VGND sg13g2_fill_2
X_4350_ _4350_/Y _9456_/Q _9455_/Q VPWR VGND sg13g2_nand2b_1
XFILLER_99_714 VPWR VGND sg13g2_fill_1
XFILLER_4_670 VPWR VGND sg13g2_decap_4
XFILLER_99_769 VPWR VGND sg13g2_decap_8
XFILLER_101_719 VPWR VGND sg13g2_decap_8
XFILLER_79_460 VPWR VGND sg13g2_decap_8
X_6020_ _6055_/B _6015_/Y _6019_/Y _6014_/Y VPWR VGND sg13g2_a21oi_1
XFILLER_79_471 VPWR VGND sg13g2_fill_1
XFILLER_67_644 VPWR VGND sg13g2_fill_2
XFILLER_66_132 VPWR VGND sg13g2_fill_1
XFILLER_81_113 VPWR VGND sg13g2_decap_8
XFILLER_54_327 VPWR VGND sg13g2_decap_8
XFILLER_54_305 VPWR VGND sg13g2_fill_1
X_7971_ _7971_/Y _7975_/A _8996_/Q _8365_/C VPWR VGND sg13g2_nand3_1
XFILLER_27_519 VPWR VGND sg13g2_decap_4
X_6922_ _6922_/X _9708_/Q _9631_/Q _6939_/B VPWR VGND sg13g2_and3_1
X_9641_ _9641_/Q _9649_/CLK _9641_/D fanout974/X VPWR VGND sg13g2_dfrbpq_1
XFILLER_81_179 VPWR VGND sg13g2_fill_1
X_6853_ _6853_/X _8900_/Q _8932_/Q _6905_/S VPWR VGND sg13g2_mux2_1
XFILLER_50_500 VPWR VGND sg13g2_fill_1
X_5804_ _5805_/A _9295_/Q _8587_/A2 _8587_/B1 _9492_/Q VPWR VGND sg13g2_a22oi_1
X_9572_ _9572_/Q _9588_/CLK _9572_/D _9572_/RESET_B VPWR VGND sg13g2_dfrbpq_1
X_6784_ _9543_/D _9543_/Q _9453_/Q _6785_/S VPWR VGND sg13g2_mux2_1
X_5735_ _5735_/Y _5735_/A _5735_/B _9312_/Q _5735_/D VPWR VGND sg13g2_nand4_1
X_8523_ _9261_/D _8523_/A VPWR VGND sg13g2_inv_1
XFILLER_108_307 VPWR VGND sg13g2_fill_1
X_8454_ _8454_/Y _8458_/A _9232_/Q _8474_/C VPWR VGND sg13g2_nand3_1
X_5666_ _8609_/D _5666_/A VPWR VGND sg13g2_inv_1
X_4617_ _6804_/B _4617_/A _4617_/B VPWR VGND sg13g2_nor2_1
X_7405_ _7407_/D _9029_/Q _7411_/B _7404_/Y VPWR VGND sg13g2_o21ai_1
XFILLER_116_340 VPWR VGND sg13g2_fill_1
X_8385_ _8385_/Y _8403_/A _9193_/Q _8403_/C VPWR VGND sg13g2_nand3_1
X_5597_ _5597_/Y _5597_/A _5597_/B _8655_/Q _5597_/D VPWR VGND sg13g2_nand4_1
XFILLER_104_513 VPWR VGND sg13g2_decap_4
X_7336_ _7336_/Y _7330_/Y _7335_/Y _7571_/B1 VPWR VGND sg13g2_o21ai_1
X_4548_ _7838_/B _5343_/B _9465_/Q VPWR VGND sg13g2_nand2_1
X_4479_ _6954_/S _8712_/Q _9654_/Q VPWR VGND sg13g2_nand2b_1
XFILLER_116_395 VPWR VGND sg13g2_decap_4
X_7267_ _7267_/Y _7248_/Y _7266_/Y _5377_/X VPWR VGND sg13g2_a21oi_1
Xfanout933 _5837_/A2 _5781_/A VPWR VGND sg13g2_buf_1
XFILLER_58_600 VPWR VGND sg13g2_decap_8
X_9006_ _9006_/Q _9501_/CLK _9006_/D place2470/X VPWR VGND sg13g2_dfrbpq_1
X_6218_ _9362_/D _6216_/Y _6279_/A _6217_/Y VPWR VGND sg13g2_a21oi_1
XFILLER_98_780 VPWR VGND sg13g2_fill_2
Xfanout977 fanout977/X fanout985/X VPWR VGND sg13g2_buf_1
Xfanout966 fanout966/X fanout967/X VPWR VGND sg13g2_buf_1
X_7198_ _7198_/Y _7198_/A _7210_/D _7221_/C _7221_/D VPWR VGND sg13g2_nand4_1
Xfanout944 fanout944/X fanout945/X VPWR VGND sg13g2_buf_1
Xfanout955 fanout955/X fanout956/X VPWR VGND sg13g2_buf_1
XFILLER_112_590 VPWR VGND sg13g2_fill_1
XFILLER_100_763 VPWR VGND sg13g2_decap_4
XFILLER_58_666 VPWR VGND sg13g2_decap_4
X_6149_ _9352_/D _6148_/Y _9352_/Q _6392_/S VPWR VGND sg13g2_mux2_1
XFILLER_38_68 VPWR VGND sg13g2_fill_1
XFILLER_72_113 VPWR VGND sg13g2_decap_8
XFILLER_45_305 VPWR VGND sg13g2_decap_4
XFILLER_81_680 VPWR VGND sg13g2_decap_8
XFILLER_54_89 VPWR VGND sg13g2_fill_1
XFILLER_54_78 VPWR VGND sg13g2_decap_4
XFILLER_13_202 VPWR VGND sg13g2_fill_1
XFILLER_14_725 VPWR VGND sg13g2_decap_4
XFILLER_110_95 VPWR VGND sg13g2_decap_8
XFILLER_41_588 VPWR VGND sg13g2_fill_2
XFILLER_70_66 VPWR VGND sg13g2_fill_1
XFILLER_70_55 VPWR VGND sg13g2_decap_8
XFILLER_70_88 VPWR VGND sg13g2_decap_8
XFILLER_123_800 VPWR VGND sg13g2_fill_1
XFILLER_119_82 VPWR VGND sg13g2_decap_8
XFILLER_79_97 VPWR VGND sg13g2_decap_8
XFILLER_122_365 VPWR VGND sg13g2_decap_4
XFILLER_68_408 VPWR VGND sg13g2_fill_2
XFILLER_1_662 VPWR VGND sg13g2_decap_4
XFILLER_49_611 VPWR VGND sg13g2_fill_2
XFILLER_76_441 VPWR VGND sg13g2_decap_4
XFILLER_64_636 VPWR VGND sg13g2_decap_4
XFILLER_49_699 VPWR VGND sg13g2_decap_4
XFILLER_63_179 VPWR VGND sg13g2_fill_2
XFILLER_17_541 VPWR VGND sg13g2_fill_1
XFILLER_20_706 VPWR VGND sg13g2_decap_8
XFILLER_32_599 VPWR VGND sg13g2_decap_4
X_5520_ _5520_/Y _9426_/Q _5615_/B _5523_/B1 _8628_/Q VPWR VGND sg13g2_a22oi_1
XFILLER_9_751 VPWR VGND sg13g2_fill_2
XFILLER_117_104 VPWR VGND sg13g2_decap_4
XFILLER_8_261 VPWR VGND sg13g2_fill_1
X_5451_ _5452_/A _5455_/A1 _8684_/Q _8685_/Q _5451_/B2 VPWR VGND sg13g2_a22oi_1
X_5382_ _7787_/B _7704_/A _7838_/B _5382_/C VPWR VGND sg13g2_nor3_1
X_8170_ _9085_/D _8190_/A1 _7892_/Y _8169_/Y VPWR VGND sg13g2_o21ai_1
X_4402_ _8670_/D _4402_/A _5438_/B_N VPWR VGND sg13g2_nor2b_1
Xoutput2679 master_addr_o[26] _9884_/X VPWR VGND sg13g2_buf_1
X_4333_ _5339_/B _9888_/A VPWR VGND sg13g2_inv_1
Xoutput2668 master_addr_o[16] _9874_/X VPWR VGND sg13g2_buf_1
X_7121_ _7121_/Y _5371_/C _7127_/A2 _7120_/Y VPWR VGND sg13g2_o21ai_1
Xoutput2657 debug_req_o _9252_/Q VPWR VGND sg13g2_buf_1
X_7052_ _7052_/Y _8034_/D _6966_/Y _7036_/X _4435_/A VPWR VGND sg13g2_a22oi_1
XFILLER_113_376 VPWR VGND sg13g2_fill_2
X_6003_ _9336_/D _6002_/Y _9336_/Q _6003_/S VPWR VGND sg13g2_mux2_1
XFILLER_101_538 VPWR VGND sg13g2_decap_8
XFILLER_39_110 VPWR VGND sg13g2_decap_8
XFILLER_28_806 VPWR VGND sg13g2_fill_2
XFILLER_39_132 VPWR VGND sg13g2_fill_2
X_7954_ _7954_/Y _8391_/C _9500_/Q _8056_/C _8068_/D VPWR VGND sg13g2_nand4_1
X_6905_ _6905_/X _8926_/Q _8958_/Q _6905_/S VPWR VGND sg13g2_mux2_1
XFILLER_70_617 VPWR VGND sg13g2_decap_8
X_7885_ _8958_/D _8958_/Q _7847_/Y _7885_/S VPWR VGND sg13g2_mux2_1
XFILLER_35_371 VPWR VGND sg13g2_decap_4
X_6836_ _9584_/D _9617_/Q _9584_/Q _6836_/S VPWR VGND sg13g2_mux2_1
XFILLER_50_352 VPWR VGND sg13g2_fill_1
X_9624_ _9624_/Q _9701_/CLK _9624_/D fanout951/X VPWR VGND sg13g2_dfrbpq_1
XFILLER_35_393 VPWR VGND sg13g2_decap_4
X_6767_ _9526_/D _9526_/Q _9436_/Q _6781_/S VPWR VGND sg13g2_mux2_1
X_9555_ _9555_/Q _9678_/CLK _9555_/D fanout967/X VPWR VGND sg13g2_dfrbpq_1
XFILLER_50_385 VPWR VGND sg13g2_decap_8
X_5718_ _5718_/Y _5749_/B _9314_/Q VPWR VGND sg13g2_nand2_1
X_8506_ _8509_/B _8744_/Q _8511_/B VPWR VGND sg13g2_nor2_1
X_9486_ _9486_/Q _9621_/CLK _9486_/D _9486_/RESET_B VPWR VGND sg13g2_dfrbpq_1
X_6698_ _9466_/D _9507_/Q _9466_/Q _6702_/S VPWR VGND sg13g2_mux2_1
XFILLER_108_159 VPWR VGND sg13g2_decap_4
X_5649_ _5650_/A _8617_/Q _5699_/A2 _5699_/B1 _8616_/Q VPWR VGND sg13g2_a22oi_1
X_8437_ _9223_/D _8444_/A _5369_/C _8436_/Y VPWR VGND sg13g2_o21ai_1
XFILLER_123_107 VPWR VGND sg13g2_fill_1
X_8368_ _9184_/D _5352_/C _8367_/A _8367_/Y VPWR VGND sg13g2_o21ai_1
X_7319_ _7319_/Y _7313_/Y _7318_/Y _7571_/B1 VPWR VGND sg13g2_o21ai_1
XFILLER_120_803 VPWR VGND sg13g2_fill_2
XFILLER_49_45 VPWR VGND sg13g2_fill_2
XFILLER_49_23 VPWR VGND sg13g2_fill_1
X_8299_ _8299_/Y _8299_/A _8299_/B VPWR VGND sg13g2_nand2_1
Xfanout774 _6348_/D slave_addr_i[5] VPWR VGND sg13g2_buf_1
Xfanout763 _6539_/S slave_req_i VPWR VGND sg13g2_buf_1
XFILLER_105_73 VPWR VGND sg13g2_decap_4
XFILLER_58_463 VPWR VGND sg13g2_fill_1
XFILLER_46_603 VPWR VGND sg13g2_decap_8
XFILLER_46_614 VPWR VGND sg13g2_fill_2
XFILLER_73_422 VPWR VGND sg13g2_decap_4
XFILLER_45_124 VPWR VGND sg13g2_decap_8
XFILLER_73_477 VPWR VGND sg13g2_fill_1
XFILLER_60_105 VPWR VGND sg13g2_decap_8
XFILLER_54_680 VPWR VGND sg13g2_decap_8
XFILLER_26_371 VPWR VGND sg13g2_decap_8
XFILLER_60_149 VPWR VGND sg13g2_fill_2
XFILLER_14_555 VPWR VGND sg13g2_fill_1
XFILLER_14_577 VPWR VGND sg13g2_fill_1
X_9536__2844 _9536_/RESET_B VPWR VGND sg13g2_tiehi
XFILLER_10_750 VPWR VGND sg13g2_fill_2
XFILLER_6_743 VPWR VGND sg13g2_decap_8
XFILLER_114_107 VPWR VGND sg13g2_fill_1
XFILLER_123_652 VPWR VGND sg13g2_decap_8
XFILLER_96_569 VPWR VGND sg13g2_decap_4
XFILLER_110_368 VPWR VGND sg13g2_fill_1
XFILLER_37_603 VPWR VGND sg13g2_decap_8
XFILLER_37_614 VPWR VGND sg13g2_fill_1
XFILLER_64_444 VPWR VGND sg13g2_decap_8
XFILLER_36_168 VPWR VGND sg13g2_decap_8
XFILLER_37_669 VPWR VGND sg13g2_decap_8
XFILLER_36_179 VPWR VGND sg13g2_fill_2
X_4951_ _4951_/Y _9397_/Q _4979_/A2 _4949_/Y _4950_/Y VPWR VGND sg13g2_a22oi_1
XFILLER_60_650 VPWR VGND sg13g2_decap_8
X_4882_ _4882_/Y _4807_/B _4880_/Y _4881_/Y VPWR VGND sg13g2_o21ai_1
X_7670_ _7672_/B _9197_/Q _7670_/B VPWR VGND sg13g2_nor2_1
X_6621_ _6621_/Y _6621_/A _6654_/B VPWR VGND sg13g2_nand2_1
XFILLER_20_503 VPWR VGND sg13g2_fill_1
X_9340_ _9340_/Q _9414_/CLK _9340_/D place2500/X VPWR VGND sg13g2_dfrbpq_1
XFILLER_72_0 VPWR VGND sg13g2_decap_8
X_6552_ _6552_/X _6558_/A _9418_/Q _6737_/A _6558_/D VPWR VGND sg13g2_and4_1
X_9271_ _9271_/Q _9305_/CLK _9271_/D place2415/X VPWR VGND sg13g2_dfrbpq_1
X_6483_ _6483_/Y _6483_/A _6483_/B VPWR VGND sg13g2_nand2_1
X_5503_ _8622_/D _5503_/A _5503_/B VPWR VGND sg13g2_nor2_1
X_8222_ _9111_/D _8222_/A1 _7951_/Y _8221_/Y VPWR VGND sg13g2_o21ai_1
XFILLER_10_28 VPWR VGND sg13g2_decap_8
X_5434_ _5434_/Y _8675_/Q _5434_/B VPWR VGND sg13g2_nor2_1
X_8153_ _8153_/Y _9077_/Q _8157_/B VPWR VGND sg13g2_nand2_1
X_5365_ _8805_/D _5366_/A _5373_/B _5365_/C _5373_/D VPWR VGND sg13g2_nor4_1
X_7104_ _8854_/D _7103_/Y _8854_/Q _7110_/S VPWR VGND sg13g2_mux2_1
X_4316_ _5159_/C _9864_/A VPWR VGND sg13g2_inv_1
X_5296_ _8776_/D _5341_/A1 _5368_/C _5295_/Y _5336_/B2 VPWR VGND sg13g2_a22oi_1
XFILLER_87_536 VPWR VGND sg13g2_decap_8
X_8084_ _9044_/D _8102_/A1 _8083_/Y _8082_/Y VPWR VGND sg13g2_o21ai_1
XFILLER_113_184 VPWR VGND sg13g2_decap_4
XFILLER_101_357 VPWR VGND sg13g2_decap_4
XFILLER_101_346 VPWR VGND sg13g2_fill_1
XFILLER_68_750 VPWR VGND sg13g2_fill_1
X_7035_ _7056_/A _7036_/B _6962_/Y _6964_/Y VPWR VGND sg13g2_o21ai_1
XFILLER_101_379 VPWR VGND sg13g2_decap_8
XFILLER_83_720 VPWR VGND sg13g2_fill_2
XFILLER_28_636 VPWR VGND sg13g2_decap_8
X_9586__2804 _9586_/RESET_B VPWR VGND sg13g2_tiehi
X_8986_ _8986_/Q _9199_/CLK _8986_/D place2427/X VPWR VGND sg13g2_dfrbpq_1
XFILLER_27_157 VPWR VGND sg13g2_decap_8
XFILLER_82_285 VPWR VGND sg13g2_decap_4
XFILLER_82_263 VPWR VGND sg13g2_fill_1
XFILLER_70_414 VPWR VGND sg13g2_fill_1
X_7937_ _8980_/D _5365_/C _7956_/A _7936_/Y VPWR VGND sg13g2_o21ai_1
X_7868_ _8942_/D _8942_/Q _7536_/Y _8514_/B VPWR VGND sg13g2_mux2_1
XFILLER_35_69 VPWR VGND sg13g2_decap_8
XFILLER_42_138 VPWR VGND sg13g2_decap_8
XFILLER_42_149 VPWR VGND sg13g2_fill_2
X_9607_ _9607_/Q _9611_/CLK _9607_/D _9607_/RESET_B VPWR VGND sg13g2_dfrbpq_1
X_6819_ _9567_/D _9600_/Q _9567_/Q _6840_/S VPWR VGND sg13g2_mux2_1
X_7799_ _7799_/X _7803_/A _7799_/B _8987_/Q VPWR VGND sg13g2_or3_1
XFILLER_50_171 VPWR VGND sg13g2_decap_8
X_9538_ _9538_/Q _9582_/CLK _9538_/D _9538_/RESET_B VPWR VGND sg13g2_dfrbpq_1
XFILLER_109_424 VPWR VGND sg13g2_fill_2
XFILLER_51_79 VPWR VGND sg13g2_fill_2
XFILLER_51_68 VPWR VGND sg13g2_decap_8
X_9469_ _9469_/Q _9501_/CLK _9469_/D _9469_/RESET_B VPWR VGND sg13g2_dfrbpq_1
XFILLER_3_735 VPWR VGND sg13g2_fill_2
XFILLER_105_641 VPWR VGND sg13g2_decap_8
XFILLER_2_245 VPWR VGND sg13g2_decap_4
XFILLER_116_50 VPWR VGND sg13g2_fill_2
XFILLER_105_696 VPWR VGND sg13g2_decap_8
XFILLER_104_151 VPWR VGND sg13g2_fill_2
XFILLER_120_666 VPWR VGND sg13g2_fill_2
XFILLER_78_558 VPWR VGND sg13g2_decap_8
XFILLER_66_709 VPWR VGND sg13g2_fill_1
XFILLER_120_677 VPWR VGND sg13g2_decap_8
XFILLER_93_517 VPWR VGND sg13g2_decap_8
XFILLER_93_506 VPWR VGND sg13g2_fill_1
XFILLER_74_742 VPWR VGND sg13g2_decap_4
XFILLER_34_617 VPWR VGND sg13g2_fill_1
XFILLER_46_455 VPWR VGND sg13g2_decap_4
XFILLER_73_263 VPWR VGND sg13g2_decap_8
XFILLER_34_628 VPWR VGND sg13g2_fill_2
XFILLER_46_499 VPWR VGND sg13g2_decap_8
XFILLER_42_650 VPWR VGND sg13g2_decap_8
XFILLER_14_396 VPWR VGND sg13g2_fill_1
Xplace2419 place2419/X place2420/X VPWR VGND sg13g2_buf_1
Xplace2408 place2408/X place2422/X VPWR VGND sg13g2_buf_1
XFILLER_115_438 VPWR VGND sg13g2_fill_1
XFILLER_6_595 VPWR VGND sg13g2_fill_1
X_5150_ _5191_/B _9863_/A _5150_/B VPWR VGND sg13g2_xor2_1
X_5081_ _8752_/D _5066_/Y _5080_/A _5344_/C _5288_/A1 VPWR VGND sg13g2_a22oi_1
XFILLER_84_539 VPWR VGND sg13g2_fill_1
XFILLER_37_411 VPWR VGND sg13g2_fill_2
X_8840_ _8840_/Q _9242_/CLK _8840_/D place2495/X VPWR VGND sg13g2_dfrbpq_1
XFILLER_37_466 VPWR VGND sg13g2_fill_2
X_5983_ _5983_/Y _5983_/A _6004_/B _6004_/C VPWR VGND sg13g2_nand3_1
XFILLER_92_594 VPWR VGND sg13g2_decap_4
X_8771_ _9877_/A _9260_/CLK _8771_/D place2400/X VPWR VGND sg13g2_dfrbpq_1
XFILLER_18_680 VPWR VGND sg13g2_fill_2
XFILLER_37_488 VPWR VGND sg13g2_fill_2
X_7722_ _7722_/Y _7744_/A _7722_/B _7722_/C _7722_/D VPWR VGND sg13g2_nor4_1
X_4934_ _4935_/C _9395_/Q _4934_/B VPWR VGND sg13g2_nand2_1
X_7653_ _7656_/B _7647_/Y _7652_/Y _4560_/B VPWR VGND sg13g2_o21ai_1
X_4865_ _4957_/C _5012_/A _5012_/B VPWR VGND sg13g2_nand2_1
Xclkbuf_leaf_8_clk_i _9603_/CLK clkload2/A VPWR VGND sg13g2_buf_16
X_6604_ _6604_/Y _6661_/C _8635_/Q _9567_/Q _6669_/B2 VPWR VGND sg13g2_a22oi_1
X_7584_ _7586_/C _7759_/A _9131_/Q _7802_/C VPWR VGND sg13g2_nor3_1
X_4796_ _4796_/Y _4792_/Y _4795_/Y _4899_/C VPWR VGND sg13g2_a21oi_1
X_9323_ _9323_/Q _9410_/CLK _9323_/D place2397/X VPWR VGND sg13g2_dfrbpq_1
X_6535_ _9410_/D _6534_/Y _6534_/A _6535_/S VPWR VGND sg13g2_mux2_1
XFILLER_20_399 VPWR VGND sg13g2_fill_1
XFILLER_119_766 VPWR VGND sg13g2_fill_2
X_9254_ _9254_/Q _9254_/CLK _9254_/D place2402/X VPWR VGND sg13g2_dfrbpq_1
XFILLER_21_49 VPWR VGND sg13g2_fill_1
X_8205_ _8205_/Y _8205_/A _8219_/B VPWR VGND sg13g2_nand2_1
X_6466_ _6466_/Y _9014_/Q _6506_/A2 _6507_/A2 _9200_/Q VPWR VGND sg13g2_a22oi_1
X_6397_ _6399_/D _6397_/A _6397_/B VPWR VGND sg13g2_and2_1
X_9185_ _9185_/Q clkload4/A _9185_/D place2486/X VPWR VGND sg13g2_dfrbpq_1
X_5417_ _5417_/Y _4389_/B _4337_/Y _8622_/Q _6545_/B VPWR VGND sg13g2_a22oi_1
X_5348_ _8788_/D _5375_/A _5375_/B _5348_/C _5375_/D VPWR VGND sg13g2_nor4_1
X_8136_ _9068_/D _8164_/A1 _7925_/Y _8135_/Y VPWR VGND sg13g2_o21ai_1
XFILLER_102_644 VPWR VGND sg13g2_decap_8
Xhold2932 _8724_/D _8723_/Q VPWR VGND sg13g2_dlygate4sd3_1
Xhold2921 _8731_/D _8730_/Q VPWR VGND sg13g2_dlygate4sd3_1
X_8067_ _8067_/Y _8067_/A _8101_/B VPWR VGND sg13g2_nand2_1
Xhold2965 _9650_/D _4483_/Y VPWR VGND sg13g2_dlygate4sd3_1
XFILLER_102_688 VPWR VGND sg13g2_fill_1
X_5279_ _5281_/B _5334_/A _5291_/B _5291_/C _5291_/D VPWR VGND sg13g2_nand4_1
X_7018_ _8157_/B _7004_/Y _7016_/Y _7029_/A VPWR VGND sg13g2_a21oi_1
Xhold2943 _9663_/D _4477_/Y VPWR VGND sg13g2_dlygate4sd3_1
Xhold2954 _6512_/B1 _9406_/Q VPWR VGND sg13g2_dlygate4sd3_1
XFILLER_47_208 VPWR VGND sg13g2_fill_2
Xhold2987 _4569_/A _4568_/Y VPWR VGND sg13g2_dlygate4sd3_1
XFILLER_68_591 VPWR VGND sg13g2_decap_8
Xhold2998 _8157_/A _9079_/Q VPWR VGND sg13g2_dlygate4sd3_1
Xhold2976 _5639_/B1 _8612_/Q VPWR VGND sg13g2_dlygate4sd3_1
XFILLER_43_414 VPWR VGND sg13g2_fill_2
XFILLER_71_745 VPWR VGND sg13g2_decap_8
X_8969_ _8969_/Q _9188_/CLK _8969_/D place2486/X VPWR VGND sg13g2_dfrbpq_1
XFILLER_71_789 VPWR VGND sg13g2_fill_1
XFILLER_70_255 VPWR VGND sg13g2_decap_4
XFILLER_24_672 VPWR VGND sg13g2_fill_2
XFILLER_11_300 VPWR VGND sg13g2_decap_8
XFILLER_24_683 VPWR VGND sg13g2_decap_4
XFILLER_11_399 VPWR VGND sg13g2_fill_2
XFILLER_109_287 VPWR VGND sg13g2_decap_8
Xclkbuf_leaf_3_jtag_tck_i_regs _9686_/CLK clkbuf_leaf_6_jtag_tck_i_regs/A VPWR VGND
+ sg13g2_buf_16
XFILLER_3_510 VPWR VGND sg13g2_fill_1
XFILLER_2_0 VPWR VGND sg13g2_decap_8
XFILLER_78_344 VPWR VGND sg13g2_decap_8
XFILLER_78_322 VPWR VGND sg13g2_decap_4
X_9486__2894 _9486_/RESET_B VPWR VGND sg13g2_tiehi
XFILLER_38_219 VPWR VGND sg13g2_decap_8
XFILLER_19_400 VPWR VGND sg13g2_fill_1
XFILLER_19_433 VPWR VGND sg13g2_decap_4
XFILLER_19_455 VPWR VGND sg13g2_decap_8
XFILLER_19_466 VPWR VGND sg13g2_fill_2
XFILLER_19_499 VPWR VGND sg13g2_fill_1
XFILLER_34_425 VPWR VGND sg13g2_decap_8
XFILLER_46_263 VPWR VGND sg13g2_fill_2
XFILLER_62_767 VPWR VGND sg13g2_fill_2
XFILLER_21_108 VPWR VGND sg13g2_decap_8
X_4650_ _4651_/C _8717_/Q _4650_/B VPWR VGND sg13g2_nor2_1
XFILLER_30_686 VPWR VGND sg13g2_decap_8
Xplace2216 _6672_/A _6661_/A VPWR VGND sg13g2_buf_1
Xplace2205 _6737_/C _9693_/Q VPWR VGND sg13g2_buf_1
X_4581_ _4582_/B _4581_/A _4581_/B VPWR VGND sg13g2_nor2_1
Xplace2227 _7822_/A _7667_/A VPWR VGND sg13g2_buf_1
X_6320_ _6320_/Y _6328_/C _6328_/A _6320_/B1 VPWR VGND sg13g2_a21oi_1
XFILLER_116_736 VPWR VGND sg13g2_decap_8
Xplace2249 _7718_/A _7839_/C VPWR VGND sg13g2_buf_1
Xplace2238 _7333_/A _7386_/A VPWR VGND sg13g2_buf_1
X_6251_ _6251_/Y _6250_/X _6430_/B2 _8855_/Q _6496_/A2 VPWR VGND sg13g2_a22oi_1
X_5202_ _8761_/D _5274_/B2 _5353_/C _5201_/Y VPWR VGND sg13g2_o21ai_1
X_6182_ _6182_/Y _8971_/Q _6410_/A _6404_/B1 _9095_/Q VPWR VGND sg13g2_a22oi_1
XFILLER_97_631 VPWR VGND sg13g2_decap_8
X_5133_ _5134_/C _5117_/B _5132_/Y _5089_/A VPWR VGND sg13g2_o21ai_1
XFILLER_35_0 VPWR VGND sg13g2_decap_8
XFILLER_111_463 VPWR VGND sg13g2_fill_1
XFILLER_97_675 VPWR VGND sg13g2_decap_8
XFILLER_96_152 VPWR VGND sg13g2_fill_1
XFILLER_96_141 VPWR VGND sg13g2_decap_8
XFILLER_85_804 VPWR VGND sg13g2_fill_1
XFILLER_97_697 VPWR VGND sg13g2_decap_4
XFILLER_96_185 VPWR VGND sg13g2_decap_8
X_5064_ _5066_/B _8528_/B _5124_/A _5129_/D _5117_/D VPWR VGND sg13g2_nand4_1
XFILLER_69_388 VPWR VGND sg13g2_decap_4
X_9872_ _9872_/X _9872_/A VPWR VGND sg13g2_buf_1
XFILLER_38_753 VPWR VGND sg13g2_fill_2
X_8823_ _8823_/Q _9504_/CLK _8823_/D place2431/X VPWR VGND sg13g2_dfrbpq_1
XFILLER_53_723 VPWR VGND sg13g2_decap_8
XFILLER_25_425 VPWR VGND sg13g2_decap_8
XFILLER_52_233 VPWR VGND sg13g2_fill_1
X_5966_ _5966_/Y _9324_/Q _5978_/B VPWR VGND sg13g2_nand2_1
XFILLER_80_586 VPWR VGND sg13g2_decap_4
XFILLER_80_564 VPWR VGND sg13g2_decap_8
X_8754_ _9860_/A _9252_/CLK _8754_/D place2391/X VPWR VGND sg13g2_dfrbpq_1
XFILLER_52_277 VPWR VGND sg13g2_fill_2
X_5897_ _5897_/Y _5897_/A _5929_/B VPWR VGND sg13g2_nor2_1
X_7705_ _7709_/A _7705_/A _7705_/B _9106_/Q VPWR VGND sg13g2_nor3_1
X_8685_ _8685_/Q _9630_/CLK _8685_/D fanout943/X VPWR VGND sg13g2_dfrbpq_1
X_4917_ _4917_/Y _4912_/X _4915_/Y _4916_/Y VPWR VGND sg13g2_o21ai_1
X_7636_ _7637_/D _7636_/A _7636_/B _7636_/C VPWR VGND sg13g2_nor3_1
X_4848_ _4848_/Y _6010_/A0 _4847_/B _4959_/C VPWR VGND sg13g2_o21ai_1
XFILLER_21_653 VPWR VGND sg13g2_decap_8
XFILLER_20_174 VPWR VGND sg13g2_decap_4
XFILLER_21_675 VPWR VGND sg13g2_decap_8
X_9306_ _9306_/Q _9410_/CLK _9306_/D place2406/X VPWR VGND sg13g2_dfrbpq_1
X_4779_ _4779_/Y _4844_/B _4761_/X _4768_/C _4778_/Y _4899_/C VPWR VGND sg13g2_a221oi_1
X_7567_ _7570_/B _7834_/A _9006_/Q _7832_/C VPWR VGND sg13g2_nor3_1
X_7498_ _7498_/Y _7498_/A _7498_/B _7498_/C VPWR VGND sg13g2_nand3_1
X_6518_ _9407_/D _9407_/Q _6484_/S _6517_/Y VPWR VGND sg13g2_a21o_1
X_9237_ _9237_/Q clkload4/A _9237_/D place2480/X VPWR VGND sg13g2_dfrbpq_1
X_6449_ _6449_/Y _8885_/Q _6511_/A2 _6447_/Y _6410_/Y _6445_/Y VPWR VGND sg13g2_a221oi_1
XFILLER_121_216 VPWR VGND sg13g2_decap_4
X_9168_ _9168_/Q _9199_/CLK _9168_/D place2425/X VPWR VGND sg13g2_dfrbpq_1
XFILLER_79_119 VPWR VGND sg13g2_decap_4
X_8119_ _8119_/Y _8119_/A _8163_/B VPWR VGND sg13g2_nand2_1
XFILLER_88_675 VPWR VGND sg13g2_decap_8
XFILLER_76_804 VPWR VGND sg13g2_fill_1
XFILLER_57_34 VPWR VGND sg13g2_decap_4
XFILLER_48_517 VPWR VGND sg13g2_fill_1
XFILLER_48_506 VPWR VGND sg13g2_decap_8
X_9099_ _9099_/Q _9501_/CLK _9099_/D place2470/X VPWR VGND sg13g2_dfrbpq_1
XFILLER_102_496 VPWR VGND sg13g2_decap_8
XFILLER_75_314 VPWR VGND sg13g2_decap_8
XFILLER_75_369 VPWR VGND sg13g2_fill_1
XFILLER_29_753 VPWR VGND sg13g2_decap_8
XFILLER_90_317 VPWR VGND sg13g2_decap_8
XFILLER_29_786 VPWR VGND sg13g2_fill_2
XFILLER_113_95 VPWR VGND sg13g2_decap_8
XFILLER_73_44 VPWR VGND sg13g2_decap_8
XFILLER_71_520 VPWR VGND sg13g2_fill_1
XFILLER_71_586 VPWR VGND sg13g2_fill_1
XFILLER_31_406 VPWR VGND sg13g2_decap_4
XFILLER_12_620 VPWR VGND sg13g2_decap_8
XFILLER_43_299 VPWR VGND sg13g2_fill_2
XFILLER_11_152 VPWR VGND sg13g2_decap_8
XFILLER_12_675 VPWR VGND sg13g2_fill_2
Xinput2650 _4435_/A slave_wdata_i[5] VPWR VGND sg13g2_buf_1
XFILLER_3_340 VPWR VGND sg13g2_decap_4
XFILLER_121_772 VPWR VGND sg13g2_fill_2
XFILLER_79_675 VPWR VGND sg13g2_decap_8
XFILLER_79_697 VPWR VGND sg13g2_decap_8
XFILLER_78_185 VPWR VGND sg13g2_fill_1
XFILLER_78_163 VPWR VGND sg13g2_decap_8
XFILLER_54_509 VPWR VGND sg13g2_fill_2
XFILLER_19_252 VPWR VGND sg13g2_decap_8
XFILLER_19_274 VPWR VGND sg13g2_decap_8
X_5820_ _5821_/A _9303_/Q _8585_/A2 _8585_/B1 _9500_/Q VPWR VGND sg13g2_a22oi_1
XFILLER_22_406 VPWR VGND sg13g2_decap_8
X_5751_ _5751_/Y _5749_/B _9308_/Q _5763_/B1 VPWR VGND sg13g2_a21oi_1
XFILLER_62_586 VPWR VGND sg13g2_fill_1
X_4702_ _9673_/D _4702_/A _4708_/A VPWR VGND sg13g2_nor2_1
X_8470_ _8470_/Y _8470_/A _8470_/B _8474_/C VPWR VGND sg13g2_nand3_1
X_5682_ _8594_/D _5682_/A VPWR VGND sg13g2_inv_1
X_7421_ _7424_/A _7486_/A _9123_/Q _7490_/C VPWR VGND sg13g2_nor3_1
XFILLER_30_450 VPWR VGND sg13g2_decap_8
X_4633_ _4634_/A _4633_/A _4633_/B _4633_/C VPWR VGND sg13g2_and3_1
Xplace2002 _5012_/B _4778_/Y VPWR VGND sg13g2_buf_1
X_4564_ _4565_/A _9640_/Q _9641_/Q VPWR VGND sg13g2_nor2_1
Xplace2024 _6702_/S _6733_/S VPWR VGND sg13g2_buf_1
Xplace2035 _6332_/B _6039_/X VPWR VGND sg13g2_buf_1
X_7352_ _7353_/D _9026_/Q _7385_/B _7351_/Y VPWR VGND sg13g2_o21ai_1
Xplace2013 _5469_/B2 _4388_/X VPWR VGND sg13g2_buf_1
Xplace2046 _5693_/B1 _5677_/B1 VPWR VGND sg13g2_buf_1
Xplace2057 _6642_/C _6622_/C VPWR VGND sg13g2_buf_1
XFILLER_104_706 VPWR VGND sg13g2_fill_1
Xplace2079 _5749_/B _5736_/A VPWR VGND sg13g2_buf_1
X_7283_ _7286_/B _9221_/Q _7520_/B _7640_/A2 _9859_/A VPWR VGND sg13g2_a22oi_1
Xplace2068 _8098_/A1 _8102_/A1 VPWR VGND sg13g2_buf_1
X_6303_ _6303_/Y _8860_/Q _6441_/A2 _6302_/X _6434_/A2 _6484_/S VPWR VGND sg13g2_a221oi_1
XFILLER_103_216 VPWR VGND sg13g2_fill_2
Xclkbuf_leaf_11_clk_i _9304_/CLK clkbuf_3_6__f_clk_i/X VPWR VGND sg13g2_buf_16
XFILLER_89_428 VPWR VGND sg13g2_decap_8
X_4495_ _7269_/A _7245_/A _7245_/C _7244_/C VPWR VGND sg13g2_nor3_1
X_9022_ _9022_/Q clkload5/A _9022_/D place2485/X VPWR VGND sg13g2_dfrbpq_1
X_6234_ _6234_/Y _6451_/D _6333_/C _8474_/B VPWR VGND sg13g2_o21ai_1
X_6165_ _6165_/Y _8843_/Q _6130_/B _6161_/Y _6332_/B _6164_/Y VPWR VGND sg13g2_a221oi_1
X_5116_ _5118_/B _5175_/B _5117_/B _5147_/D _5117_/D VPWR VGND sg13g2_and4_1
Xclkbuf_leaf_26_clk_i _9692_/CLK clkbuf_3_2__f_clk_i/X VPWR VGND sg13g2_buf_16
X_6096_ _6097_/D _9235_/Q _9242_/Q VPWR VGND sg13g2_nor2b_1
X_5047_ _5048_/D _5085_/D _5124_/A _9858_/A _5084_/A _5044_/Y VPWR VGND sg13g2_a221oi_1
XFILLER_72_317 VPWR VGND sg13g2_fill_2
XFILLER_26_723 VPWR VGND sg13g2_decap_8
XFILLER_38_561 VPWR VGND sg13g2_fill_2
XFILLER_26_745 VPWR VGND sg13g2_fill_2
X_6998_ _6998_/Y _6998_/A _6998_/B _6998_/C VPWR VGND sg13g2_nand3_1
X_8806_ _8806_/Q _9252_/CLK _8806_/D place2403/X VPWR VGND sg13g2_dfrbpq_1
XFILLER_26_778 VPWR VGND sg13g2_decap_4
X_5949_ _5949_/Y _9485_/Q _5781_/Y _5948_/Y VPWR VGND sg13g2_a21oi_1
X_8737_ _8737_/Q _9678_/CLK _8737_/D fanout965/X VPWR VGND sg13g2_dfrbpq_1
XFILLER_25_299 VPWR VGND sg13g2_fill_1
X_8668_ _8668_/Q _8678_/CLK _8668_/D fanout945/X VPWR VGND sg13g2_dfrbpq_1
XFILLER_21_472 VPWR VGND sg13g2_decap_8
X_7619_ _7621_/B _8852_/Q _7846_/A2 _4293_/Y _7269_/X VPWR VGND sg13g2_a22oi_1
X_8599_ _8599_/Q _9708_/CLK _8599_/D fanout947/X VPWR VGND sg13g2_dfrbpq_1
XFILLER_21_483 VPWR VGND sg13g2_fill_1
XFILLER_122_503 VPWR VGND sg13g2_decap_4
XFILLER_108_84 VPWR VGND sg13g2_decap_8
XFILLER_68_44 VPWR VGND sg13g2_fill_2
Xplace1890 _7238_/A1 _6959_/Y VPWR VGND sg13g2_buf_1
XFILLER_0_343 VPWR VGND sg13g2_decap_8
XFILLER_68_99 VPWR VGND sg13g2_decap_8
XFILLER_0_387 VPWR VGND sg13g2_decap_8
XFILLER_84_21 VPWR VGND sg13g2_decap_4
XFILLER_76_678 VPWR VGND sg13g2_fill_1
XFILLER_48_358 VPWR VGND sg13g2_fill_1
XFILLER_17_712 VPWR VGND sg13g2_decap_4
XFILLER_29_561 VPWR VGND sg13g2_fill_1
XFILLER_90_147 VPWR VGND sg13g2_fill_1
XFILLER_63_339 VPWR VGND sg13g2_decap_4
XFILLER_44_542 VPWR VGND sg13g2_decap_8
XFILLER_90_158 VPWR VGND sg13g2_fill_2
XFILLER_71_361 VPWR VGND sg13g2_fill_1
XFILLER_17_70 VPWR VGND sg13g2_fill_2
XFILLER_32_715 VPWR VGND sg13g2_decap_8
XFILLER_8_498 VPWR VGND sg13g2_fill_1
XFILLER_100_219 VPWR VGND sg13g2_fill_1
XFILLER_94_420 VPWR VGND sg13g2_decap_8
XFILLER_67_623 VPWR VGND sg13g2_fill_2
XFILLER_67_612 VPWR VGND sg13g2_decap_8
XFILLER_94_431 VPWR VGND sg13g2_fill_1
XFILLER_94_475 VPWR VGND sg13g2_fill_1
X_7970_ _8995_/D _5349_/C _7969_/A _7969_/Y VPWR VGND sg13g2_o21ai_1
XFILLER_82_659 VPWR VGND sg13g2_fill_1
X_6921_ _9625_/D _9625_/Q _6915_/B _6920_/X VPWR VGND sg13g2_a21o_1
X_9640_ _9640_/Q _9649_/CLK _9640_/D fanout974/X VPWR VGND sg13g2_dfrbpq_1
XFILLER_81_169 VPWR VGND sg13g2_decap_4
X_6852_ _9592_/D _6851_/X _9592_/Q _6906_/S VPWR VGND sg13g2_mux2_1
XFILLER_35_542 VPWR VGND sg13g2_decap_4
X_5803_ _9294_/D _5803_/A VPWR VGND sg13g2_inv_1
X_9571_ _9571_/Q _9588_/CLK _9571_/D _9571_/RESET_B VPWR VGND sg13g2_dfrbpq_1
XFILLER_23_748 VPWR VGND sg13g2_decap_8
X_8522_ _8523_/A _5123_/B _8516_/X _8519_/Y _9490_/Q VPWR VGND sg13g2_a22oi_1
X_6783_ _9542_/D _9542_/Q _9452_/Q _6783_/S VPWR VGND sg13g2_mux2_1
X_5734_ _5734_/Y _5924_/D _5740_/A2 _5732_/Y _5733_/Y VPWR VGND sg13g2_a22oi_1
X_8453_ _9231_/D _8458_/A _5345_/C _8452_/Y VPWR VGND sg13g2_o21ai_1
X_5665_ _5666_/A _8606_/Q _5677_/A2 _5677_/B1 _5665_/B2 VPWR VGND sg13g2_a22oi_1
X_4616_ _4617_/B _4616_/A _4715_/A VPWR VGND sg13g2_nor2_1
X_7404_ _7404_/Y _9060_/Q _7404_/B _7404_/C VPWR VGND sg13g2_nand3b_1
X_8384_ _9192_/D _5360_/C _8383_/A _8383_/Y VPWR VGND sg13g2_o21ai_1
X_5596_ _8653_/D _5595_/Y _5594_/Y _6546_/D VPWR VGND sg13g2_a21oi_1
X_7335_ _7335_/Y _7389_/A _7335_/B _7335_/C _7335_/D VPWR VGND sg13g2_nor4_1
XFILLER_116_363 VPWR VGND sg13g2_fill_2
X_4547_ _7431_/D _5826_/A _5383_/B VPWR VGND sg13g2_nor2b_1
XFILLER_2_619 VPWR VGND sg13g2_decap_4
X_4478_ _4687_/A _8712_/Q _9654_/Q VPWR VGND sg13g2_nor2b_1
X_7266_ _7266_/Y _7266_/A _7259_/Y VPWR VGND sg13g2_nor2b_1
Xfanout934 _5781_/A master_rvalid_i VPWR VGND sg13g2_buf_1
X_7197_ _8882_/D _7196_/Y _8882_/Q _7213_/S VPWR VGND sg13g2_mux2_1
X_9005_ _9005_/Q clkload7/A _9005_/D place2457/X VPWR VGND sg13g2_dfrbpq_1
X_6217_ _6217_/Y _6512_/A1 _6512_/A2 _6217_/B1 VPWR VGND sg13g2_a21oi_1
XFILLER_98_770 VPWR VGND sg13g2_fill_2
XFILLER_85_420 VPWR VGND sg13g2_decap_8
Xfanout967 fanout967/X fanout972/X VPWR VGND sg13g2_buf_1
Xfanout945 fanout945/X fanout946/X VPWR VGND sg13g2_buf_1
X_6148_ _6148_/Y _6399_/B _6145_/Y _6147_/Y VPWR VGND sg13g2_o21ai_1
Xfanout956 fanout956/X fanout985/X VPWR VGND sg13g2_buf_1
Xfanout978 fanout978/X fanout984/X VPWR VGND sg13g2_buf_1
X_6079_ _6080_/C _6079_/A _9235_/Q _6247_/C VPWR VGND sg13g2_nand3_1
XFILLER_18_509 VPWR VGND sg13g2_fill_2
XFILLER_54_46 VPWR VGND sg13g2_decap_8
XFILLER_53_383 VPWR VGND sg13g2_decap_8
XFILLER_13_225 VPWR VGND sg13g2_decap_4
XFILLER_41_512 VPWR VGND sg13g2_fill_2
XFILLER_70_78 VPWR VGND sg13g2_fill_1
XFILLER_5_413 VPWR VGND sg13g2_decap_8
XFILLER_119_61 VPWR VGND sg13g2_decap_8
XFILLER_5_424 VPWR VGND sg13g2_fill_1
XFILLER_102_0 VPWR VGND sg13g2_decap_4
XFILLER_96_718 VPWR VGND sg13g2_fill_1
XFILLER_110_517 VPWR VGND sg13g2_decap_4
XFILLER_89_770 VPWR VGND sg13g2_decap_4
XFILLER_49_601 VPWR VGND sg13g2_decap_4
XFILLER_95_64 VPWR VGND sg13g2_decap_8
XFILLER_49_645 VPWR VGND sg13g2_fill_2
XFILLER_0_195 VPWR VGND sg13g2_decap_8
Xhold3090 _5679_/B2 _8593_/Q VPWR VGND sg13g2_dlygate4sd3_1
XFILLER_28_80 VPWR VGND sg13g2_fill_2
XFILLER_28_91 VPWR VGND sg13g2_fill_2
XFILLER_91_478 VPWR VGND sg13g2_fill_1
XFILLER_17_564 VPWR VGND sg13g2_decap_8
XFILLER_32_512 VPWR VGND sg13g2_decap_8
XFILLER_44_394 VPWR VGND sg13g2_decap_8
XFILLER_13_770 VPWR VGND sg13g2_fill_1
XFILLER_9_730 VPWR VGND sg13g2_decap_8
XFILLER_8_240 VPWR VGND sg13g2_fill_1
X_5450_ _8683_/D _5450_/A _5454_/B_N VPWR VGND sg13g2_nor2b_1
X_4401_ _4402_/A _4401_/A1 _5435_/A2 _4400_/Y VPWR VGND sg13g2_a21oi_1
X_5381_ _8520_/D _7735_/A _8515_/A _5387_/B _7735_/B VPWR VGND sg13g2_nand4_1
XFILLER_113_311 VPWR VGND sg13g2_fill_2
XFILLER_99_534 VPWR VGND sg13g2_decap_8
Xoutput2669 master_addr_o[17] _9875_/X VPWR VGND sg13g2_buf_1
X_4332_ _5339_/C _9887_/A VPWR VGND sg13g2_inv_1
Xoutput2658 dmactive_o _9221_/D VPWR VGND sg13g2_buf_1
X_7120_ _7120_/Y _7224_/B _7221_/B _7123_/C VPWR VGND sg13g2_nand3_1
X_7051_ _8837_/D _7050_/A _7049_/Y _7050_/Y VPWR VGND sg13g2_o21ai_1
XFILLER_113_388 VPWR VGND sg13g2_decap_8
X_6002_ _6002_/Y _6519_/A _5374_/C _6001_/Y VPWR VGND sg13g2_o21ai_1
XFILLER_101_517 VPWR VGND sg13g2_decap_8
XFILLER_67_431 VPWR VGND sg13g2_fill_2
XFILLER_95_795 VPWR VGND sg13g2_fill_1
XFILLER_95_773 VPWR VGND sg13g2_decap_4
XFILLER_39_177 VPWR VGND sg13g2_decap_8
XFILLER_94_283 VPWR VGND sg13g2_fill_2
XFILLER_54_125 VPWR VGND sg13g2_fill_1
X_7953_ _7953_/Y _7953_/A _8988_/Q _8409_/C VPWR VGND sg13g2_nand3_1
XFILLER_39_199 VPWR VGND sg13g2_fill_1
X_6904_ _9618_/D _6903_/X _9618_/Q _6904_/S VPWR VGND sg13g2_mux2_1
X_9499__2881 _9499_/RESET_B VPWR VGND sg13g2_tiehi
X_7884_ _8957_/D _8957_/Q _7829_/Y _7884_/S VPWR VGND sg13g2_mux2_1
XFILLER_70_629 VPWR VGND sg13g2_fill_1
X_6835_ _9583_/D _9616_/Q _9583_/Q _6836_/S VPWR VGND sg13g2_mux2_1
X_9623_ _9623_/Q _9701_/CLK _9623_/D fanout951/X VPWR VGND sg13g2_dfrbpq_1
X_6766_ _9525_/D _9525_/Q _9435_/Q _6781_/S VPWR VGND sg13g2_mux2_1
X_9554_ _9554_/Q _9678_/CLK _9554_/D fanout965/X VPWR VGND sg13g2_dfrbpq_1
X_5717_ _5717_/Y _5735_/A _5735_/B _9306_/Q _5735_/D VPWR VGND sg13g2_nand4_1
X_8505_ _8507_/C _8511_/B _9256_/Q VPWR VGND sg13g2_and2_1
X_9485_ _9485_/Q _9621_/CLK _9485_/D _9485_/RESET_B VPWR VGND sg13g2_dfrbpq_1
XFILLER_108_105 VPWR VGND sg13g2_decap_8
X_6697_ _9465_/D _9506_/Q _7410_/A _6702_/S VPWR VGND sg13g2_mux2_1
XFILLER_108_127 VPWR VGND sg13g2_decap_8
X_5648_ _8615_/D _5648_/A VPWR VGND sg13g2_inv_1
X_8436_ _8436_/Y _8444_/A _9223_/Q _8444_/C VPWR VGND sg13g2_nand3_1
XFILLER_117_661 VPWR VGND sg13g2_fill_2
X_5579_ _5579_/Y _9446_/Q _5579_/B VPWR VGND sg13g2_nand2_1
X_8367_ _8367_/Y _8367_/A _9184_/Q _8383_/C VPWR VGND sg13g2_nand3_1
XFILLER_123_119 VPWR VGND sg13g2_decap_8
XFILLER_116_171 VPWR VGND sg13g2_decap_8
X_7318_ _7318_/Y _7389_/A _7318_/B _7318_/C _7318_/D VPWR VGND sg13g2_nor4_1
XFILLER_6_7 VPWR VGND sg13g2_decap_8
X_8298_ _9149_/D _8350_/A1 _7897_/Y _8297_/Y VPWR VGND sg13g2_o21ai_1
X_7249_ _7249_/Y _9052_/Q _7297_/B _7278_/C VPWR VGND sg13g2_nand3b_1
XFILLER_2_449 VPWR VGND sg13g2_decap_4
XFILLER_104_388 VPWR VGND sg13g2_decap_8
Xfanout775 _6041_/A slave_addr_i[5] VPWR VGND sg13g2_buf_1
Xfanout764 _8820_/D slave_req_i VPWR VGND sg13g2_buf_1
XFILLER_100_561 VPWR VGND sg13g2_decap_8
XFILLER_86_784 VPWR VGND sg13g2_fill_1
XFILLER_58_475 VPWR VGND sg13g2_decap_8
XFILLER_18_306 VPWR VGND sg13g2_fill_1
XFILLER_45_103 VPWR VGND sg13g2_decap_8
XFILLER_46_637 VPWR VGND sg13g2_decap_4
XFILLER_33_309 VPWR VGND sg13g2_decap_8
XFILLER_14_512 VPWR VGND sg13g2_decap_8
XFILLER_14_523 VPWR VGND sg13g2_fill_1
XFILLER_26_394 VPWR VGND sg13g2_fill_2
XFILLER_41_397 VPWR VGND sg13g2_decap_8
XFILLER_14_93 VPWR VGND sg13g2_decap_4
XFILLER_10_773 VPWR VGND sg13g2_decap_4
XFILLER_5_210 VPWR VGND sg13g2_fill_1
XFILLER_123_631 VPWR VGND sg13g2_decap_8
XFILLER_107_182 VPWR VGND sg13g2_decap_4
XFILLER_96_504 VPWR VGND sg13g2_decap_8
XFILLER_122_163 VPWR VGND sg13g2_decap_8
XFILLER_68_206 VPWR VGND sg13g2_fill_1
XFILLER_110_336 VPWR VGND sg13g2_fill_2
XFILLER_77_740 VPWR VGND sg13g2_decap_4
XFILLER_37_659 VPWR VGND sg13g2_fill_2
XFILLER_52_629 VPWR VGND sg13g2_decap_4
X_4950_ _4950_/Y _4813_/A _4903_/D _5000_/B1 VPWR VGND sg13g2_a21oi_1
XFILLER_17_383 VPWR VGND sg13g2_fill_2
X_4881_ _4881_/Y _9388_/Q _4891_/A2 _4877_/Y VPWR VGND sg13g2_a21oi_1
X_6620_ _9437_/D _6656_/A1 _6619_/Y _6617_/Y VPWR VGND sg13g2_o21ai_1
XFILLER_32_386 VPWR VGND sg13g2_fill_1
X_6551_ _9417_/D _8658_/Q _6544_/Y _6550_/X VPWR VGND sg13g2_a21o_1
X_5502_ _5503_/B _8623_/Q _5499_/Y _5497_/Y VPWR VGND sg13g2_o21ai_1
XFILLER_118_447 VPWR VGND sg13g2_fill_2
X_9270_ _9270_/Q _9615_/CLK _9270_/D place2420/X VPWR VGND sg13g2_dfrbpq_1
XFILLER_65_0 VPWR VGND sg13g2_decap_8
X_6482_ _6483_/A _9236_/Q _6516_/B _6516_/C _6516_/D VPWR VGND sg13g2_nand4_1
X_8221_ _8221_/Y _8221_/A _8221_/B VPWR VGND sg13g2_nand2_1
X_5433_ _8671_/D _5433_/A _5438_/B_N VPWR VGND sg13g2_nor2b_1
X_5364_ _8804_/D _5366_/A _5366_/B _5364_/C _5366_/D VPWR VGND sg13g2_nor4_1
X_8152_ _9076_/D _8164_/A1 _8086_/Y _8151_/Y VPWR VGND sg13g2_o21ai_1
XFILLER_102_804 VPWR VGND sg13g2_fill_1
X_4315_ _5115_/D _9861_/A VPWR VGND sg13g2_inv_1
X_7103_ _7103_/Y _5365_/C _7130_/A2 _7102_/Y VPWR VGND sg13g2_o21ai_1
XFILLER_114_697 VPWR VGND sg13g2_fill_2
XFILLER_113_141 VPWR VGND sg13g2_decap_4
XFILLER_101_314 VPWR VGND sg13g2_decap_4
X_5295_ _5295_/Y _5295_/A _5295_/B VPWR VGND sg13g2_nand2_1
XFILLER_87_515 VPWR VGND sg13g2_decap_4
X_8083_ _8083_/Y _8092_/A _9494_/Q _8498_/D _8083_/D VPWR VGND sg13g2_nand4_1
X_7034_ _8832_/D _5337_/Y _8397_/A _7033_/Y VPWR VGND sg13g2_o21ai_1
XFILLER_68_762 VPWR VGND sg13g2_fill_1
XFILLER_28_604 VPWR VGND sg13g2_decap_8
XFILLER_95_592 VPWR VGND sg13g2_decap_8
XFILLER_27_114 VPWR VGND sg13g2_decap_8
X_8985_ _8985_/Q _9199_/CLK _8985_/D place2424/X VPWR VGND sg13g2_dfrbpq_1
XFILLER_82_275 VPWR VGND sg13g2_fill_1
X_7936_ _7936_/Y _7956_/A _8980_/Q _8056_/A VPWR VGND sg13g2_nand3_1
X_7867_ _8941_/D _8941_/Q _7517_/Y _7883_/S VPWR VGND sg13g2_mux2_1
XFILLER_70_448 VPWR VGND sg13g2_decap_8
X_9606_ _9606_/Q _9611_/CLK _9606_/D _9606_/RESET_B VPWR VGND sg13g2_dfrbpq_1
X_6818_ _9566_/D _9599_/Q _9566_/Q _6839_/S VPWR VGND sg13g2_mux2_1
XFILLER_50_150 VPWR VGND sg13g2_decap_4
XFILLER_11_504 VPWR VGND sg13g2_fill_2
XFILLER_23_375 VPWR VGND sg13g2_decap_4
X_7798_ _7801_/C _7803_/A _9018_/Q _7802_/C VPWR VGND sg13g2_nor3_1
XFILLER_50_194 VPWR VGND sg13g2_decap_8
XFILLER_11_548 VPWR VGND sg13g2_fill_1
X_9537_ _9537_/Q _9582_/CLK _9537_/D _9537_/RESET_B VPWR VGND sg13g2_dfrbpq_1
X_6749_ _9508_/D _9508_/Q _9418_/Q _6756_/S VPWR VGND sg13g2_mux2_1
X_9468_ _9468_/Q _9501_/CLK _9468_/D _9468_/RESET_B VPWR VGND sg13g2_dfrbpq_1
X_8419_ _9213_/D _5360_/C _8430_/A _8418_/Y VPWR VGND sg13g2_o21ai_1
X_9399_ _9399_/Q _9406_/CLK _9399_/D place2488/X VPWR VGND sg13g2_dfrbpq_1
XFILLER_59_784 VPWR VGND sg13g2_fill_2
XFILLER_19_604 VPWR VGND sg13g2_fill_2
XFILLER_74_721 VPWR VGND sg13g2_decap_8
XFILLER_74_710 VPWR VGND sg13g2_fill_1
XFILLER_100_391 VPWR VGND sg13g2_decap_8
XFILLER_74_776 VPWR VGND sg13g2_fill_1
XFILLER_34_607 VPWR VGND sg13g2_fill_1
XFILLER_74_787 VPWR VGND sg13g2_fill_2
XFILLER_73_286 VPWR VGND sg13g2_fill_2
XFILLER_92_76 VPWR VGND sg13g2_decap_8
XFILLER_42_640 VPWR VGND sg13g2_fill_2
XFILLER_42_673 VPWR VGND sg13g2_fill_1
Xplace2409 place2409/X place2421/X VPWR VGND sg13g2_buf_1
XFILLER_10_570 VPWR VGND sg13g2_fill_2
XFILLER_115_406 VPWR VGND sg13g2_decap_4
XFILLER_6_541 VPWR VGND sg13g2_decap_8
XFILLER_123_461 VPWR VGND sg13g2_decap_8
XFILLER_69_504 VPWR VGND sg13g2_fill_2
X_5080_ _5080_/Y _5080_/A _8426_/C VPWR VGND sg13g2_nand2_1
XFILLER_69_548 VPWR VGND sg13g2_fill_1
XFILLER_111_678 VPWR VGND sg13g2_fill_2
XFILLER_96_378 VPWR VGND sg13g2_decap_8
XFILLER_110_188 VPWR VGND sg13g2_fill_1
XFILLER_77_570 VPWR VGND sg13g2_fill_2
XFILLER_65_743 VPWR VGND sg13g2_decap_8
XFILLER_49_283 VPWR VGND sg13g2_fill_2
XFILLER_49_272 VPWR VGND sg13g2_fill_1
XFILLER_65_776 VPWR VGND sg13g2_decap_8
X_5982_ _9329_/D _5981_/B _5980_/Y _5981_/Y VPWR VGND sg13g2_o21ai_1
X_8770_ _9876_/A _9260_/CLK _8770_/D place2392/X VPWR VGND sg13g2_dfrbpq_1
XFILLER_65_787 VPWR VGND sg13g2_fill_1
XFILLER_80_768 VPWR VGND sg13g2_decap_8
X_7721_ _7722_/D _9014_/Q _4550_/Y _7720_/Y VPWR VGND sg13g2_o21ai_1
X_4933_ _4935_/B _4903_/Y _4932_/Y _5006_/A1 VPWR VGND sg13g2_a21o_1
X_7652_ _7652_/Y _7652_/A _7652_/B _7652_/C _7652_/D VPWR VGND sg13g2_nor4_1
X_4864_ _4864_/Y _4864_/A1 _4859_/Y _4863_/Y VPWR VGND sg13g2_o21ai_1
XFILLER_32_183 VPWR VGND sg13g2_decap_8
XFILLER_119_701 VPWR VGND sg13g2_decap_8
X_7583_ _7586_/B _9162_/Q _7767_/B VPWR VGND sg13g2_nor2_1
X_6603_ _6603_/Y _6603_/A _6660_/B VPWR VGND sg13g2_nand2_1
X_4795_ _4795_/Y _4816_/A _4795_/B VPWR VGND sg13g2_nor2_1
XFILLER_119_734 VPWR VGND sg13g2_decap_8
X_9322_ _9322_/Q _9410_/CLK _9322_/D place2396/X VPWR VGND sg13g2_dfrbpq_1
X_6534_ _6534_/Y _6534_/A _6534_/B _6534_/C _6534_/D VPWR VGND sg13g2_nor4_1
XFILLER_118_233 VPWR VGND sg13g2_fill_1
X_9253_ _9253_/Q _9253_/CLK _9253_/D place2426/X VPWR VGND sg13g2_dfrbpq_1
X_6465_ _6465_/Y _9076_/Q _6506_/B1 _6507_/B1 _9138_/Q VPWR VGND sg13g2_a22oi_1
X_8204_ _9102_/D _5836_/D _8071_/Y _8203_/Y VPWR VGND sg13g2_o21ai_1
X_5416_ _6545_/B _5629_/C _5416_/B VPWR VGND sg13g2_and2_1
X_9184_ _9184_/Q clkload8/A _9184_/D place2467/X VPWR VGND sg13g2_dfrbpq_1
X_6396_ _9387_/D _6432_/S _6394_/Y _6395_/Y VPWR VGND sg13g2_a21oi_1
XFILLER_102_601 VPWR VGND sg13g2_fill_2
XFILLER_99_172 VPWR VGND sg13g2_decap_8
X_5347_ _8787_/D _5360_/A _5360_/B _5347_/C _5360_/D VPWR VGND sg13g2_nor4_1
X_8135_ _8135_/Y _8135_/A _8163_/B VPWR VGND sg13g2_nand2_1
X_8066_ _9038_/D _5372_/D _7928_/Y _8065_/Y VPWR VGND sg13g2_o21ai_1
Xhold2922 _8703_/D _8702_/Q VPWR VGND sg13g2_dlygate4sd3_1
X_5278_ _5291_/D _9878_/A _9879_/A _9880_/A VPWR VGND sg13g2_and3_1
XFILLER_101_144 VPWR VGND sg13g2_fill_2
XFILLER_87_356 VPWR VGND sg13g2_decap_8
Xhold2933 _8734_/D _8733_/Q VPWR VGND sg13g2_dlygate4sd3_1
Xhold2966 _6069_/B1 _9345_/Q VPWR VGND sg13g2_dlygate4sd3_1
Xhold2955 _4579_/B _9697_/Q VPWR VGND sg13g2_dlygate4sd3_1
X_7017_ _7017_/Y _7407_/A _7410_/A _7834_/B VPWR VGND sg13g2_nand3b_1
Xhold2944 _6415_/B1 _9390_/Q VPWR VGND sg13g2_dlygate4sd3_1
XFILLER_101_166 VPWR VGND sg13g2_decap_4
Xhold2988 _9667_/D _4569_/Y VPWR VGND sg13g2_dlygate4sd3_1
XFILLER_75_529 VPWR VGND sg13g2_decap_8
XFILLER_56_710 VPWR VGND sg13g2_fill_1
XFILLER_28_401 VPWR VGND sg13g2_decap_4
Xhold2977 _8612_/D _5640_/Y VPWR VGND sg13g2_dlygate4sd3_1
Xhold2999 _6320_/B1 _9373_/Q VPWR VGND sg13g2_dlygate4sd3_1
XFILLER_83_551 VPWR VGND sg13g2_decap_4
XFILLER_71_713 VPWR VGND sg13g2_decap_8
XFILLER_55_264 VPWR VGND sg13g2_fill_1
X_8968_ _8968_/Q clkload4/A _8968_/D place2486/X VPWR VGND sg13g2_dfrbpq_1
XFILLER_43_426 VPWR VGND sg13g2_decap_8
XFILLER_46_69 VPWR VGND sg13g2_decap_8
X_7919_ _7919_/Y _7924_/A _8973_/Q _8056_/A VPWR VGND sg13g2_nand3_1
XFILLER_43_437 VPWR VGND sg13g2_fill_2
X_8899_ _8899_/Q _9198_/CLK _8899_/D place2452/X VPWR VGND sg13g2_dfrbpq_1
XFILLER_24_651 VPWR VGND sg13g2_decap_8
XFILLER_23_161 VPWR VGND sg13g2_fill_2
XFILLER_109_266 VPWR VGND sg13g2_decap_8
XFILLER_11_94 VPWR VGND sg13g2_decap_8
XFILLER_11_83 VPWR VGND sg13g2_decap_4
XFILLER_79_802 VPWR VGND sg13g2_fill_2
XFILLER_87_65 VPWR VGND sg13g2_decap_4
XFILLER_78_367 VPWR VGND sg13g2_fill_1
XFILLER_120_497 VPWR VGND sg13g2_decap_8
XFILLER_93_326 VPWR VGND sg13g2_decap_8
XFILLER_59_581 VPWR VGND sg13g2_fill_1
XFILLER_19_412 VPWR VGND sg13g2_decap_8
XFILLER_61_201 VPWR VGND sg13g2_decap_4
XFILLER_62_746 VPWR VGND sg13g2_fill_1
XFILLER_14_172 VPWR VGND sg13g2_decap_4
XFILLER_42_470 VPWR VGND sg13g2_fill_1
X_4580_ _9700_/D _4590_/C _4580_/B VPWR VGND sg13g2_and2_1
XFILLER_30_676 VPWR VGND sg13g2_decap_4
Xplace2217 _6661_/A _9588_/Q VPWR VGND sg13g2_buf_1
Xplace2228 _7801_/A _7785_/A VPWR VGND sg13g2_buf_1
Xplace2206 _7028_/B _6309_/A VPWR VGND sg13g2_buf_1
XFILLER_116_715 VPWR VGND sg13g2_decap_8
Xplace2239 _7386_/A _7404_/C VPWR VGND sg13g2_buf_1
X_9613__2777 _9613_/RESET_B VPWR VGND sg13g2_tiehi
X_6250_ _6250_/X _8981_/Q _9043_/Q _9105_/Q _9167_/Q _6514_/S0 _6514_/S1 VPWR VGND
+ sg13g2_mux4_1
X_5201_ _5201_/Y _5198_/Y _5201_/B _5268_/C VPWR VGND sg13g2_nand3b_1
X_6181_ _6181_/Y _6181_/A _6399_/C VPWR VGND sg13g2_nand2_1
X_5132_ _5132_/Y _5132_/A _5132_/B _9259_/Q _5132_/D VPWR VGND sg13g2_nor4_1
XFILLER_69_323 VPWR VGND sg13g2_fill_2
XFILLER_84_304 VPWR VGND sg13g2_fill_1
XFILLER_28_0 VPWR VGND sg13g2_decap_8
X_5063_ _5065_/D _5147_/D _5098_/A _9262_/Q _5123_/A VPWR VGND sg13g2_nand4_1
X_9871_ _9871_/X _9871_/A VPWR VGND sg13g2_buf_1
XFILLER_65_551 VPWR VGND sg13g2_fill_2
X_8822_ _8822_/Q _9407_/CLK _8822_/D place2488/X VPWR VGND sg13g2_dfrbpq_1
XFILLER_25_404 VPWR VGND sg13g2_decap_8
XFILLER_65_595 VPWR VGND sg13g2_fill_2
XFILLER_25_437 VPWR VGND sg13g2_decap_8
XFILLER_37_286 VPWR VGND sg13g2_fill_2
X_5965_ _5965_/Y _9489_/Q _5980_/A2 _5849_/X _5980_/B2 VPWR VGND sg13g2_a22oi_1
X_8753_ _8753_/Q _9260_/CLK _8753_/D place2392/X VPWR VGND sg13g2_dfrbpq_1
X_5896_ _5896_/Y _9314_/Q _5963_/B VPWR VGND sg13g2_nand2_1
X_7704_ _7704_/Y _7704_/A _7704_/B _7704_/C _7704_/D VPWR VGND sg13g2_nor4_1
X_8684_ _8684_/Q _9630_/CLK _8684_/D fanout943/X VPWR VGND sg13g2_dfrbpq_1
X_4916_ _4916_/Y _9392_/Q _4979_/A2 _4911_/Y VPWR VGND sg13g2_a21oi_1
X_7635_ _7636_/B _7635_/A _7635_/B VPWR VGND sg13g2_nand2_1
X_4847_ _4847_/Y _9341_/Q _4847_/B VPWR VGND sg13g2_nor2_1
XFILLER_20_120 VPWR VGND sg13g2_decap_8
XFILLER_21_632 VPWR VGND sg13g2_decap_8
X_9305_ _9305_/Q _9305_/CLK _9305_/D place2415/X VPWR VGND sg13g2_dfrbpq_1
X_4778_ _4778_/Y _4945_/A _4816_/B VPWR VGND sg13g2_nand2_1
X_7566_ _7566_/X _7834_/A _7834_/B _8975_/Q VPWR VGND sg13g2_or3_1
X_7497_ _7498_/C _5238_/A _5383_/Y _5412_/C _6309_/A VPWR VGND sg13g2_a22oi_1
X_6517_ _6517_/Y _6515_/Y _6516_/Y _6484_/S VPWR VGND sg13g2_a21oi_1
X_9236_ _9236_/Q _9251_/CLK _9236_/D place2478/X VPWR VGND sg13g2_dfrbpq_1
X_6448_ _6448_/Y _6371_/A _6371_/B _6448_/B1 VPWR VGND sg13g2_o21ai_1
X_9167_ _9167_/Q _9620_/CLK _9167_/D place2438/X VPWR VGND sg13g2_dfrbpq_1
X_6379_ _6379_/Y _6379_/A1 _6379_/A2 _6379_/B1 VPWR VGND sg13g2_a21oi_1
XFILLER_0_547 VPWR VGND sg13g2_decap_8
X_8118_ _9059_/D _8120_/A1 _8039_/Y _8117_/Y VPWR VGND sg13g2_o21ai_1
XFILLER_88_654 VPWR VGND sg13g2_decap_8
XFILLER_87_131 VPWR VGND sg13g2_fill_1
X_9098_ _9098_/Q _9254_/CLK _9098_/D place2453/X VPWR VGND sg13g2_dfrbpq_1
XFILLER_102_486 VPWR VGND sg13g2_decap_8
XFILLER_48_529 VPWR VGND sg13g2_fill_1
X_8049_ _8049_/Y _8049_/A _8055_/B VPWR VGND sg13g2_nand2_1
XFILLER_91_808 VPWR VGND sg13g2_fill_1
XFILLER_16_404 VPWR VGND sg13g2_decap_8
XFILLER_29_798 VPWR VGND sg13g2_fill_2
XFILLER_71_565 VPWR VGND sg13g2_decap_8
XFILLER_43_245 VPWR VGND sg13g2_fill_1
XFILLER_43_256 VPWR VGND sg13g2_decap_8
XFILLER_44_768 VPWR VGND sg13g2_fill_2
XFILLER_31_429 VPWR VGND sg13g2_fill_2
XFILLER_24_492 VPWR VGND sg13g2_fill_2
XFILLER_8_614 VPWR VGND sg13g2_fill_2
Xinput2651 _4435_/D slave_wdata_i[6] VPWR VGND sg13g2_buf_1
Xinput2640 _7218_/A slave_wdata_i[25] VPWR VGND sg13g2_buf_1
XFILLER_7_179 VPWR VGND sg13g2_decap_8
XFILLER_106_792 VPWR VGND sg13g2_fill_1
XFILLER_106_781 VPWR VGND sg13g2_decap_8
XFILLER_79_632 VPWR VGND sg13g2_decap_4
XFILLER_78_142 VPWR VGND sg13g2_fill_2
Xclkbuf_leaf_7_clk_i _9621_/CLK clkload2/A VPWR VGND sg13g2_buf_16
XFILLER_120_294 VPWR VGND sg13g2_fill_1
XFILLER_120_283 VPWR VGND sg13g2_decap_8
XFILLER_94_668 VPWR VGND sg13g2_fill_2
XFILLER_82_808 VPWR VGND sg13g2_fill_1
XFILLER_19_242 VPWR VGND sg13g2_decap_4
XFILLER_35_713 VPWR VGND sg13g2_decap_8
XFILLER_62_510 VPWR VGND sg13g2_fill_2
XFILLER_34_212 VPWR VGND sg13g2_fill_2
XFILLER_35_768 VPWR VGND sg13g2_fill_2
X_5750_ _5750_/Y _9316_/Q _5749_/B _5749_/Y VPWR VGND sg13g2_o21ai_1
X_4701_ _9674_/D _4701_/A _4701_/B VPWR VGND sg13g2_nor2_1
X_5681_ _5682_/A _8595_/Q _5693_/A2 _5693_/B1 _5681_/B2 VPWR VGND sg13g2_a22oi_1
X_4632_ _6743_/D _9644_/Q _9647_/Q _9646_/Q VPWR VGND sg13g2_or3_1
X_7420_ _7424_/C _9185_/Q _7485_/B _7489_/A VPWR VGND sg13g2_o21ai_1
Xplace2003 _5602_/B1 _6546_/D VPWR VGND sg13g2_buf_1
Xplace2036 _5980_/B2 _6004_/B VPWR VGND sg13g2_buf_1
X_4563_ _8749_/D _8448_/A _4562_/Y _7029_/A VPWR VGND sg13g2_a21oi_1
Xplace2025 _6733_/S _6714_/S VPWR VGND sg13g2_buf_1
Xplace2014 _5435_/A2 _5439_/A1 VPWR VGND sg13g2_buf_1
X_7351_ _7351_/Y _9057_/Q _7351_/B _7351_/C VPWR VGND sg13g2_nand3b_1
XFILLER_8_95 VPWR VGND sg13g2_decap_4
Xplace2058 _6622_/C _6661_/C VPWR VGND sg13g2_buf_1
Xplace2069 _5372_/D _8102_/A1 VPWR VGND sg13g2_buf_1
X_7282_ _7282_/Y _9253_/Q _4523_/B _7787_/B _8785_/Q VPWR VGND sg13g2_a22oi_1
X_6302_ _6302_/X _8986_/Q _9048_/Q _9110_/Q _9172_/Q _6302_/S0 _6440_/S1 VPWR VGND
+ sg13g2_mux4_1
X_4494_ _7244_/C _9470_/Q _7245_/B VPWR VGND sg13g2_nand2b_1
XFILLER_7_691 VPWR VGND sg13g2_fill_2
Xplace2047 _5677_/B1 _5629_/Y VPWR VGND sg13g2_buf_1
XFILLER_104_729 VPWR VGND sg13g2_decap_8
XFILLER_89_407 VPWR VGND sg13g2_decap_8
X_9021_ _9021_/Q clkload5/A _9021_/D place2485/X VPWR VGND sg13g2_dfrbpq_1
X_6233_ _9364_/D _6229_/Y _6231_/Y _6232_/Y VPWR VGND sg13g2_a21oi_1
XFILLER_85_602 VPWR VGND sg13g2_decap_4
X_6164_ _6164_/Y _6162_/Y _6163_/Y _6044_/C VPWR VGND sg13g2_a21oi_1
X_5115_ _5117_/B _5132_/A _5132_/B _5160_/B _5115_/D VPWR VGND sg13g2_nor4_1
XFILLER_85_624 VPWR VGND sg13g2_fill_1
XFILLER_85_613 VPWR VGND sg13g2_decap_8
XFILLER_57_326 VPWR VGND sg13g2_fill_1
X_6095_ _6097_/C _9230_/Q _9232_/Q _9234_/Q VPWR VGND sg13g2_nor3_1
X_5046_ _5046_/Y _5055_/A _5057_/A _5098_/A _5046_/D VPWR VGND sg13g2_nor4_1
XFILLER_85_668 VPWR VGND sg13g2_decap_8
XFILLER_85_657 VPWR VGND sg13g2_decap_4
XFILLER_38_551 VPWR VGND sg13g2_fill_1
XFILLER_65_370 VPWR VGND sg13g2_decap_8
XFILLER_26_757 VPWR VGND sg13g2_decap_8
X_6997_ _6998_/B _8815_/Q _7824_/B _7694_/B _9889_/A VPWR VGND sg13g2_a22oi_1
X_8805_ _8805_/Q _9219_/CLK _8805_/D place2403/X VPWR VGND sg13g2_dfrbpq_1
XFILLER_25_267 VPWR VGND sg13g2_decap_8
X_5948_ _5948_/Y _5939_/Y _5947_/Y _5945_/Y _5946_/Y VPWR VGND sg13g2_a22oi_1
XFILLER_80_395 VPWR VGND sg13g2_fill_2
X_8736_ _8736_/Q _9678_/CLK _8736_/D fanout965/X VPWR VGND sg13g2_dfrbpq_1
XFILLER_53_598 VPWR VGND sg13g2_decap_8
XFILLER_41_749 VPWR VGND sg13g2_decap_4
X_5879_ _9311_/D _9311_/Q _5920_/B _5878_/Y VPWR VGND sg13g2_a21o_1
X_8667_ _8667_/Q _8678_/CLK _8667_/D fanout946/X VPWR VGND sg13g2_dfrbpq_1
X_7618_ _7621_/A _9293_/Q _7796_/A2 _7796_/B1 _9325_/Q VPWR VGND sg13g2_a22oi_1
X_8598_ _8598_/Q _9708_/CLK _8598_/D fanout947/X VPWR VGND sg13g2_dfrbpq_1
XFILLER_119_350 VPWR VGND sg13g2_decap_8
X_7549_ _7553_/A _7543_/Y _7548_/Y _4560_/B VPWR VGND sg13g2_o21ai_1
XFILLER_4_127 VPWR VGND sg13g2_decap_4
XFILLER_107_589 VPWR VGND sg13g2_fill_1
XFILLER_107_578 VPWR VGND sg13g2_decap_8
X_9219_ _9219_/Q _9219_/CLK _9219_/D place2409/X VPWR VGND sg13g2_dfrbpq_1
Xplace1880 _7774_/S _7812_/S VPWR VGND sg13g2_buf_1
Xplace1891 _6781_/S _6786_/S VPWR VGND sg13g2_buf_1
XFILLER_76_635 VPWR VGND sg13g2_fill_2
XFILLER_0_366 VPWR VGND sg13g2_decap_8
XFILLER_48_315 VPWR VGND sg13g2_decap_4
XFILLER_75_134 VPWR VGND sg13g2_fill_1
XFILLER_29_540 VPWR VGND sg13g2_decap_8
XFILLER_63_318 VPWR VGND sg13g2_fill_2
XFILLER_29_551 VPWR VGND sg13g2_fill_1
XFILLER_84_88 VPWR VGND sg13g2_fill_1
XFILLER_44_565 VPWR VGND sg13g2_fill_1
XFILLER_8_422 VPWR VGND sg13g2_decap_4
XFILLER_33_92 VPWR VGND sg13g2_decap_8
XFILLER_117_309 VPWR VGND sg13g2_fill_1
XFILLER_8_466 VPWR VGND sg13g2_decap_8
XFILLER_99_727 VPWR VGND sg13g2_decap_4
XFILLER_99_705 VPWR VGND sg13g2_fill_1
XFILLER_99_749 VPWR VGND sg13g2_decap_8
X_9522__2858 _9522_/RESET_B VPWR VGND sg13g2_tiehi
XFILLER_3_160 VPWR VGND sg13g2_fill_2
XFILLER_94_443 VPWR VGND sg13g2_decap_8
XFILLER_67_646 VPWR VGND sg13g2_fill_1
XFILLER_67_679 VPWR VGND sg13g2_decap_8
XFILLER_66_178 VPWR VGND sg13g2_fill_2
XFILLER_47_381 VPWR VGND sg13g2_decap_8
X_6920_ _6920_/X _9708_/Q _9630_/Q _6939_/B VPWR VGND sg13g2_and3_1
XFILLER_81_148 VPWR VGND sg13g2_decap_8
X_6851_ _6851_/X _8899_/Q _8931_/Q _6905_/S VPWR VGND sg13g2_mux2_1
X_5802_ _5803_/A _9294_/Q _8579_/A2 _8579_/B1 _9491_/Q VPWR VGND sg13g2_a22oi_1
X_9570_ _9570_/Q _9588_/CLK _9570_/D _9570_/RESET_B VPWR VGND sg13g2_dfrbpq_1
XFILLER_90_671 VPWR VGND sg13g2_decap_4
X_8521_ _9260_/D _5187_/A _8516_/X _8520_/Y VPWR VGND sg13g2_a21o_1
XFILLER_95_0 VPWR VGND sg13g2_decap_8
X_6782_ _9541_/D _9541_/Q _9451_/Q _6785_/S VPWR VGND sg13g2_mux2_1
XFILLER_50_546 VPWR VGND sg13g2_fill_2
XFILLER_50_535 VPWR VGND sg13g2_decap_8
X_5733_ _5733_/Y _5739_/A _9319_/Q VPWR VGND sg13g2_nand2_1
X_8452_ _8452_/Y _8470_/A _9231_/Q _8474_/C VPWR VGND sg13g2_nand3_1
X_5664_ _8608_/D _5664_/A VPWR VGND sg13g2_inv_1
XFILLER_31_793 VPWR VGND sg13g2_fill_1
X_5595_ _5595_/Y _8654_/Q _5498_/X _5601_/B1 _8653_/Q VPWR VGND sg13g2_a22oi_1
X_4615_ _4616_/A _9548_/Q _9547_/Q VPWR VGND sg13g2_nand2b_1
X_7403_ _7407_/B _7410_/A _7834_/B _8967_/Q VPWR VGND sg13g2_nor3_1
X_8383_ _8383_/Y _8383_/A _9192_/Q _8383_/C VPWR VGND sg13g2_nand3_1
X_4546_ _4562_/B _6523_/A _5403_/B _5400_/A _5400_/C VPWR VGND sg13g2_nand4_1
X_7334_ _7335_/D _9025_/Q _7385_/B _7331_/Y VPWR VGND sg13g2_o21ai_1
XFILLER_2_609 VPWR VGND sg13g2_fill_1
XFILLER_104_537 VPWR VGND sg13g2_decap_8
XFILLER_104_526 VPWR VGND sg13g2_decap_4
X_4477_ _4477_/Y hold2942/X _4477_/B VPWR VGND sg13g2_nand2b_1
X_7265_ _7266_/A _7265_/A _7265_/B _7265_/C _7265_/D VPWR VGND sg13g2_nand4_1
X_7196_ _7196_/Y _7238_/A1 _7194_/Y _7195_/Y VPWR VGND sg13g2_a21oi_1
X_9004_ _9004_/Q clkload8/A _9004_/D place2475/X VPWR VGND sg13g2_dfrbpq_1
X_6216_ _6216_/Y _8851_/Q _6411_/A2 _6215_/X _6430_/B2 _6178_/Y VPWR VGND sg13g2_a221oi_1
Xfanout935 _5123_/A _6519_/A VPWR VGND sg13g2_buf_1
XFILLER_98_782 VPWR VGND sg13g2_fill_1
Xfanout968 fanout968/X fanout969/X VPWR VGND sg13g2_buf_1
Xfanout946 fanout946/X fanout956/X VPWR VGND sg13g2_buf_1
X_6147_ _6147_/Y _8841_/Q _6462_/A2 _6146_/X _6401_/B2 VPWR VGND sg13g2_a22oi_1
Xfanout957 fanout957/X fanout959/X VPWR VGND sg13g2_buf_1
Xfanout979 fanout979/X fanout984/X VPWR VGND sg13g2_buf_1
XFILLER_38_48 VPWR VGND sg13g2_fill_1
X_6078_ _6079_/A _6438_/B _6189_/C VPWR VGND sg13g2_nand2_1
X_5029_ _5029_/Y _5124_/A _5110_/A _5084_/A _5085_/C VPWR VGND sg13g2_a22oi_1
XFILLER_54_25 VPWR VGND sg13g2_decap_8
XFILLER_14_705 VPWR VGND sg13g2_decap_8
XFILLER_26_565 VPWR VGND sg13g2_decap_8
XFILLER_53_362 VPWR VGND sg13g2_fill_2
X_9572__2818 _9572_/RESET_B VPWR VGND sg13g2_tiehi
X_8719_ _8719_/Q _9675_/CLK _8719_/D place2446/X VPWR VGND sg13g2_dfrbpq_1
X_9699_ _9699_/Q _9708_/CLK _9699_/D fanout953/X VPWR VGND sg13g2_dfrbpq_1
XFILLER_119_51 VPWR VGND sg13g2_fill_1
XFILLER_79_44 VPWR VGND sg13g2_fill_2
XFILLER_79_55 VPWR VGND sg13g2_fill_2
XFILLER_110_507 VPWR VGND sg13g2_fill_1
XFILLER_1_653 VPWR VGND sg13g2_decap_4
XFILLER_49_624 VPWR VGND sg13g2_decap_8
XFILLER_49_613 VPWR VGND sg13g2_fill_1
XFILLER_95_43 VPWR VGND sg13g2_decap_8
Xhold3080 _8257_/A _9129_/Q VPWR VGND sg13g2_dlygate4sd3_1
XFILLER_49_657 VPWR VGND sg13g2_decap_8
Xhold3091 _5680_/A _5679_/Y VPWR VGND sg13g2_dlygate4sd3_1
XFILLER_64_616 VPWR VGND sg13g2_fill_1
XFILLER_64_605 VPWR VGND sg13g2_decap_8
XFILLER_17_521 VPWR VGND sg13g2_decap_4
XFILLER_91_468 VPWR VGND sg13g2_fill_2
XFILLER_17_532 VPWR VGND sg13g2_decap_8
Xclkbuf_leaf_10_clk_i _9199_/CLK clkbuf_leaf_9_clk_i/A VPWR VGND sg13g2_buf_16
XFILLER_44_373 VPWR VGND sg13g2_decap_8
XFILLER_71_192 VPWR VGND sg13g2_decap_4
XFILLER_13_760 VPWR VGND sg13g2_fill_1
XFILLER_32_579 VPWR VGND sg13g2_fill_1
XFILLER_40_590 VPWR VGND sg13g2_decap_8
XFILLER_8_252 VPWR VGND sg13g2_decap_8
Xclkbuf_leaf_25_clk_i _9414_/CLK clkbuf_3_2__f_clk_i/X VPWR VGND sg13g2_buf_16
X_4400_ _4400_/Y _8671_/Q _5434_/B VPWR VGND sg13g2_nor2_1
X_5380_ _5380_/Y _5827_/A _5383_/B _5826_/A _7775_/D VPWR VGND sg13g2_nor4_1
X_4331_ _5339_/D _9886_/A VPWR VGND sg13g2_inv_1
Xoutput2659 jtag_tdo_o _8663_/Q VPWR VGND sg13g2_buf_1
XFILLER_87_708 VPWR VGND sg13g2_decap_8
XFILLER_4_480 VPWR VGND sg13g2_decap_4
X_7050_ _7050_/Y _7050_/A _8837_/Q VPWR VGND sg13g2_nand2_1
X_6001_ _6001_/Y _6001_/A _6004_/B _6004_/C VPWR VGND sg13g2_nand3_1
XFILLER_86_229 VPWR VGND sg13g2_fill_2
XFILLER_67_410 VPWR VGND sg13g2_fill_1
XFILLER_39_134 VPWR VGND sg13g2_fill_1
XFILLER_10_0 VPWR VGND sg13g2_decap_8
XFILLER_28_808 VPWR VGND sg13g2_fill_1
XFILLER_82_424 VPWR VGND sg13g2_decap_8
XFILLER_82_413 VPWR VGND sg13g2_decap_8
X_7952_ _8987_/D _5372_/C _7950_/A _7950_/Y VPWR VGND sg13g2_o21ai_1
XFILLER_55_638 VPWR VGND sg13g2_decap_8
XFILLER_55_627 VPWR VGND sg13g2_fill_1
X_6903_ _6903_/X _8925_/Q _8957_/Q _9255_/Q VPWR VGND sg13g2_mux2_1
X_7883_ _8956_/D _8956_/Q _7811_/Y _7883_/S VPWR VGND sg13g2_mux2_1
X_9622_ _9622_/Q _9672_/CLK _9622_/D place2442/X VPWR VGND sg13g2_dfrbpq_1
XFILLER_23_524 VPWR VGND sg13g2_decap_4
X_6834_ _9582_/D _9615_/Q _9582_/Q _6834_/S VPWR VGND sg13g2_mux2_1
XFILLER_50_343 VPWR VGND sg13g2_decap_8
XFILLER_50_321 VPWR VGND sg13g2_decap_4
XFILLER_23_557 VPWR VGND sg13g2_decap_8
X_6765_ _9524_/D _9524_/Q _9434_/Q _6781_/S VPWR VGND sg13g2_mux2_1
X_9553_ _9553_/Q _9686_/CLK _9553_/D fanout965/X VPWR VGND sg13g2_dfrbpq_1
XFILLER_50_365 VPWR VGND sg13g2_decap_8
X_9484_ _9484_/Q _9621_/CLK _9484_/D _9484_/RESET_B VPWR VGND sg13g2_dfrbpq_1
X_5716_ _5716_/X _5716_/A _9313_/Q _5716_/C VPWR VGND sg13g2_and3_1
X_8504_ _8507_/B _9256_/Q _8511_/B VPWR VGND sg13g2_nor2_1
XFILLER_10_229 VPWR VGND sg13g2_decap_4
XFILLER_40_27 VPWR VGND sg13g2_fill_1
X_6696_ _9464_/D _9505_/Q _9464_/Q _6702_/S VPWR VGND sg13g2_mux2_1
X_8435_ _9222_/D _8444_/A _5368_/C _8434_/Y VPWR VGND sg13g2_o21ai_1
X_5647_ _5648_/A _8616_/Q _5699_/A2 _5699_/B1 _5647_/B2 VPWR VGND sg13g2_a22oi_1
X_5578_ _8647_/D _5577_/Y _5576_/Y _5581_/B1 VPWR VGND sg13g2_a21oi_1
X_8366_ _9183_/D _5351_/C _8367_/A _8365_/Y VPWR VGND sg13g2_o21ai_1
XFILLER_117_695 VPWR VGND sg13g2_fill_1
XFILLER_117_684 VPWR VGND sg13g2_fill_2
XFILLER_116_150 VPWR VGND sg13g2_fill_2
X_8297_ _8297_/Y _8297_/A _8349_/B VPWR VGND sg13g2_nand2_1
X_7317_ _7318_/D _8993_/Q _4550_/Y _7316_/Y VPWR VGND sg13g2_o21ai_1
X_4529_ _4529_/Y _9465_/Q _9464_/Q VPWR VGND sg13g2_nand2_1
X_7248_ _7248_/Y _9274_/Q _5785_/C _5828_/Y _9306_/Q _7247_/Y VPWR VGND sg13g2_a221oi_1
XFILLER_49_14 VPWR VGND sg13g2_decap_8
XFILLER_105_31 VPWR VGND sg13g2_fill_1
XFILLER_105_20 VPWR VGND sg13g2_decap_8
X_7179_ _7179_/Y _7179_/A _7182_/D _7207_/C _7179_/D VPWR VGND sg13g2_nand4_1
XFILLER_86_774 VPWR VGND sg13g2_decap_4
XFILLER_73_402 VPWR VGND sg13g2_fill_1
XFILLER_85_295 VPWR VGND sg13g2_decap_8
XFILLER_18_318 VPWR VGND sg13g2_decap_4
XFILLER_39_690 VPWR VGND sg13g2_fill_2
XFILLER_73_468 VPWR VGND sg13g2_decap_8
XFILLER_54_693 VPWR VGND sg13g2_decap_8
XFILLER_14_535 VPWR VGND sg13g2_decap_4
XFILLER_81_67 VPWR VGND sg13g2_decap_8
XFILLER_14_568 VPWR VGND sg13g2_decap_8
XFILLER_41_343 VPWR VGND sg13g2_decap_4
XFILLER_41_376 VPWR VGND sg13g2_decap_4
XFILLER_6_723 VPWR VGND sg13g2_fill_2
XFILLER_123_610 VPWR VGND sg13g2_decap_8
XFILLER_108_695 VPWR VGND sg13g2_decap_8
XFILLER_110_304 VPWR VGND sg13g2_decap_4
XFILLER_96_527 VPWR VGND sg13g2_fill_1
XFILLER_49_476 VPWR VGND sg13g2_fill_1
XFILLER_49_465 VPWR VGND sg13g2_decap_8
XFILLER_64_413 VPWR VGND sg13g2_decap_8
XFILLER_36_137 VPWR VGND sg13g2_decap_4
XFILLER_51_107 VPWR VGND sg13g2_decap_8
XFILLER_45_660 VPWR VGND sg13g2_decap_8
XFILLER_60_630 VPWR VGND sg13g2_fill_2
X_4880_ _4880_/Y _4903_/B _4880_/B _4880_/C _4880_/D VPWR VGND sg13g2_nand4_1
X_6550_ _6550_/X _6558_/A _9417_/Q _6737_/A _6558_/D VPWR VGND sg13g2_and4_1
X_5501_ _5503_/A _6545_/B _5629_/A _8622_/Q VPWR VGND sg13g2_a21oi_1
X_6481_ _6483_/B _8890_/Q _7237_/B2 _6515_/B1 _6480_/X VPWR VGND sg13g2_a22oi_1
X_8220_ _9110_/D _8226_/A1 _8095_/Y _8219_/Y VPWR VGND sg13g2_o21ai_1
X_5432_ _5433_/A _5432_/A1 _5435_/A2 _5431_/Y VPWR VGND sg13g2_a21oi_1
X_5363_ _8803_/D _8563_/B _5375_/B _5363_/C _5375_/D VPWR VGND sg13g2_nor4_1
XFILLER_58_0 VPWR VGND sg13g2_decap_8
X_8151_ _8151_/Y _9076_/Q _8163_/B VPWR VGND sg13g2_nand2_1
XFILLER_113_120 VPWR VGND sg13g2_decap_8
X_4314_ _5132_/D _9860_/A VPWR VGND sg13g2_inv_1
X_7102_ _7102_/Y _7204_/A _7207_/B _7105_/C VPWR VGND sg13g2_nand3_1
X_5294_ _5295_/B _5316_/A _5329_/B _9882_/A VPWR VGND sg13g2_nand3_1
X_8082_ _8082_/Y _8082_/A _8097_/B VPWR VGND sg13g2_nand2_1
XFILLER_101_337 VPWR VGND sg13g2_decap_8
X_7033_ _7033_/Y _8397_/A _8832_/Q _8089_/A VPWR VGND sg13g2_nand3_1
XFILLER_95_571 VPWR VGND sg13g2_decap_8
XFILLER_83_722 VPWR VGND sg13g2_fill_1
XFILLER_55_435 VPWR VGND sg13g2_decap_8
X_8984_ _8984_/Q _9198_/CLK _8984_/D place2436/X VPWR VGND sg13g2_dfrbpq_1
XFILLER_27_137 VPWR VGND sg13g2_decap_4
XFILLER_70_405 VPWR VGND sg13g2_fill_1
X_7935_ _8979_/D _8489_/A2 _7948_/A _7934_/Y VPWR VGND sg13g2_o21ai_1
X_7866_ _8940_/D _7499_/Y _8514_/B _7865_/Y VPWR VGND sg13g2_a21oi_1
X_9605_ _9605_/Q _9621_/CLK _9605_/D _9605_/RESET_B VPWR VGND sg13g2_dfrbpq_1
X_6817_ _9565_/D _9598_/Q _9565_/Q _6836_/S VPWR VGND sg13g2_mux2_1
X_9536_ _9536_/Q _9567_/CLK _9536_/D _9536_/RESET_B VPWR VGND sg13g2_dfrbpq_1
X_7797_ _7801_/B _9080_/Q _7804_/B VPWR VGND sg13g2_nor2_1
X_6748_ _9507_/D _9507_/Q _9417_/Q _6756_/S VPWR VGND sg13g2_mux2_1
X_6679_ _9456_/D _6678_/B _6677_/Y _6678_/Y VPWR VGND sg13g2_a21oi_1
X_9467_ _9467_/Q _9501_/CLK _9467_/D _9467_/RESET_B VPWR VGND sg13g2_dfrbpq_1
X_8418_ _8418_/Y _8430_/A _9213_/Q _8430_/C VPWR VGND sg13g2_nand3_1
X_9398_ _9398_/Q _9406_/CLK _9398_/D place2489/X VPWR VGND sg13g2_dfrbpq_1
XFILLER_3_715 VPWR VGND sg13g2_decap_8
XFILLER_2_214 VPWR VGND sg13g2_decap_8
X_8349_ _8349_/Y _8349_/A _8349_/B VPWR VGND sg13g2_nand2_1
XFILLER_3_748 VPWR VGND sg13g2_decap_8
XFILLER_120_613 VPWR VGND sg13g2_decap_4
XFILLER_104_153 VPWR VGND sg13g2_fill_1
XFILLER_2_258 VPWR VGND sg13g2_decap_8
XFILLER_116_63 VPWR VGND sg13g2_decap_8
XFILLER_116_52 VPWR VGND sg13g2_fill_1
Xclkbuf_0_jtag_tck_i clkbuf_0_jtag_tck_i/X jtag_tck_i VPWR VGND sg13g2_buf_8
XFILLER_74_755 VPWR VGND sg13g2_fill_1
XFILLER_73_243 VPWR VGND sg13g2_decap_8
XFILLER_73_298 VPWR VGND sg13g2_decap_4
XFILLER_10_582 VPWR VGND sg13g2_decap_4
XFILLER_97_803 VPWR VGND sg13g2_fill_2
XFILLER_96_335 VPWR VGND sg13g2_decap_8
XFILLER_2_770 VPWR VGND sg13g2_decap_8
XFILLER_110_134 VPWR VGND sg13g2_fill_2
XFILLER_2_42 VPWR VGND sg13g2_decap_8
XFILLER_65_711 VPWR VGND sg13g2_decap_8
XFILLER_37_402 VPWR VGND sg13g2_decap_4
X_5981_ _5981_/Y _9329_/Q _5981_/B VPWR VGND sg13g2_nand2_1
XFILLER_25_608 VPWR VGND sg13g2_decap_4
XFILLER_37_468 VPWR VGND sg13g2_fill_1
XFILLER_80_747 VPWR VGND sg13g2_decap_8
XFILLER_52_438 VPWR VGND sg13g2_decap_8
X_7720_ _7720_/Y _9076_/Q _7831_/A _7839_/C VPWR VGND sg13g2_nand3b_1
X_4932_ _4932_/Y _4994_/A _9363_/Q VPWR VGND sg13g2_nand2b_1
XFILLER_33_630 VPWR VGND sg13g2_fill_1
X_7651_ _7652_/C _7651_/A _7783_/B _9103_/Q VPWR VGND sg13g2_nor3_1
XFILLER_33_641 VPWR VGND sg13g2_fill_1
XFILLER_33_652 VPWR VGND sg13g2_decap_8
X_6602_ _9432_/D _6663_/A1 _6601_/Y _6600_/Y VPWR VGND sg13g2_o21ai_1
XFILLER_60_471 VPWR VGND sg13g2_decap_8
X_4863_ _4863_/Y _9386_/Q _4770_/Y _4862_/Y VPWR VGND sg13g2_a21oi_1
XFILLER_33_685 VPWR VGND sg13g2_decap_8
X_7582_ _7586_/A _7759_/A _7799_/B _9100_/Q VPWR VGND sg13g2_nor3_1
X_4794_ _4795_/B _9340_/Q _4820_/B _6010_/A0 VPWR VGND sg13g2_a21oi_1
X_9321_ _9321_/Q _9409_/CLK _9321_/D place2396/X VPWR VGND sg13g2_dfrbpq_1
X_6533_ _9409_/D _6532_/Y _5070_/C _6535_/S VPWR VGND sg13g2_mux2_1
XFILLER_119_768 VPWR VGND sg13g2_fill_1
X_9252_ _9252_/Q _9252_/CLK _9252_/D place2401/X VPWR VGND sg13g2_dfrbpq_1
X_6464_ _9399_/D _6505_/A2 _6462_/Y _6463_/Y VPWR VGND sg13g2_a21oi_1
X_8203_ _8203_/Y _8203_/A _8219_/B VPWR VGND sg13g2_nand2_1
X_5415_ _8748_/D _5415_/A _5415_/B VPWR VGND sg13g2_nor2_1
X_9183_ _9183_/Q _9183_/CLK _9183_/D place2483/X VPWR VGND sg13g2_dfrbpq_1
X_6395_ _6395_/Y _6512_/A1 _6512_/A2 _6395_/B1 VPWR VGND sg13g2_a21oi_1
X_5346_ _8786_/D _5360_/A _5360_/B _5346_/C _5360_/D VPWR VGND sg13g2_nor4_1
X_8134_ _9067_/D _8160_/A1 _8061_/Y _8133_/Y VPWR VGND sg13g2_o21ai_1
XFILLER_101_123 VPWR VGND sg13g2_decap_8
XFILLER_101_112 VPWR VGND sg13g2_fill_1
X_8065_ _8065_/Y _8065_/A _8097_/B VPWR VGND sg13g2_nand2_1
X_5277_ _5281_/A _5276_/Y _5254_/C _4325_/Y VPWR VGND sg13g2_o21ai_1
Xhold2923 _8722_/D _8721_/Q VPWR VGND sg13g2_dlygate4sd3_1
Xhold2934 _8704_/D _8703_/Q VPWR VGND sg13g2_dlygate4sd3_1
X_7016_ _7016_/Y _7431_/A _7670_/B VPWR VGND sg13g2_nor2_1
Xhold2956 _6057_/B1 _9344_/Q VPWR VGND sg13g2_dlygate4sd3_1
Xhold2945 _6379_/B1 _9383_/Q VPWR VGND sg13g2_dlygate4sd3_1
XFILLER_68_571 VPWR VGND sg13g2_decap_8
Xhold2989 _6437_/B1 _9396_/Q VPWR VGND sg13g2_dlygate4sd3_1
Xhold2967 _6140_/B1 _9351_/Q VPWR VGND sg13g2_dlygate4sd3_1
Xhold2978 _5642_/B1 _8613_/Q VPWR VGND sg13g2_dlygate4sd3_1
X_9535__2845 _9535_/RESET_B VPWR VGND sg13g2_tiehi
XFILLER_83_541 VPWR VGND sg13g2_fill_1
XFILLER_83_585 VPWR VGND sg13g2_fill_2
XFILLER_83_574 VPWR VGND sg13g2_fill_1
XFILLER_83_563 VPWR VGND sg13g2_decap_8
X_8967_ _8967_/Q clkload8/A _8967_/D place2472/X VPWR VGND sg13g2_dfrbpq_1
XFILLER_24_630 VPWR VGND sg13g2_decap_8
X_7918_ _8972_/D _5357_/C _7917_/A _7917_/Y VPWR VGND sg13g2_o21ai_1
X_8898_ _8898_/Q _9198_/CLK _8898_/D place2438/X VPWR VGND sg13g2_dfrbpq_1
XFILLER_23_140 VPWR VGND sg13g2_decap_8
X_7849_ _7849_/Y _9258_/Q _8513_/B _7849_/B1 VPWR VGND sg13g2_a21oi_1
XFILLER_109_201 VPWR VGND sg13g2_decap_8
X_9519_ _9519_/Q _9686_/CLK _9519_/D _9519_/RESET_B VPWR VGND sg13g2_dfrbpq_1
XFILLER_11_379 VPWR VGND sg13g2_decap_8
XFILLER_11_51 VPWR VGND sg13g2_fill_1
XFILLER_3_523 VPWR VGND sg13g2_decap_4
XFILLER_105_473 VPWR VGND sg13g2_decap_8
XFILLER_87_99 VPWR VGND sg13g2_fill_2
XFILLER_120_476 VPWR VGND sg13g2_decap_8
XFILLER_46_221 VPWR VGND sg13g2_decap_8
XFILLER_19_479 VPWR VGND sg13g2_decap_8
XFILLER_34_405 VPWR VGND sg13g2_fill_2
XFILLER_46_276 VPWR VGND sg13g2_fill_2
XFILLER_62_769 VPWR VGND sg13g2_fill_1
XFILLER_42_482 VPWR VGND sg13g2_decap_4
XFILLER_14_195 VPWR VGND sg13g2_decap_4
Xplace2218 _7735_/A _7811_/A VPWR VGND sg13g2_buf_1
Xplace2207 _6309_/A _9690_/Q VPWR VGND sg13g2_buf_1
XFILLER_115_215 VPWR VGND sg13g2_decap_8
Xplace2229 _7785_/A _7744_/A VPWR VGND sg13g2_buf_1
XFILLER_115_226 VPWR VGND sg13g2_fill_2
X_9585__2805 _9585_/RESET_B VPWR VGND sg13g2_tiehi
X_5200_ _5201_/B _5215_/A _9867_/A _9866_/A VPWR VGND sg13g2_nand3_1
X_6180_ _6399_/C _6438_/B _6189_/C _9249_/Q VPWR VGND sg13g2_a21oi_1
XFILLER_123_270 VPWR VGND sg13g2_fill_2
X_5131_ _5191_/A _5166_/A _5166_/B VPWR VGND sg13g2_nand2_1
XFILLER_123_292 VPWR VGND sg13g2_decap_4
XFILLER_111_454 VPWR VGND sg13g2_decap_8
XFILLER_97_666 VPWR VGND sg13g2_decap_4
X_5062_ _5089_/A _5126_/B _5124_/B _6519_/D VPWR VGND sg13g2_nor3_1
XFILLER_69_346 VPWR VGND sg13g2_decap_8
XFILLER_57_519 VPWR VGND sg13g2_decap_8
XFILLER_77_390 VPWR VGND sg13g2_fill_2
X_9870_ _9870_/X _9870_/A VPWR VGND sg13g2_buf_1
X_8821_ _8821_/Q _9407_/CLK _8821_/D place2454/X VPWR VGND sg13g2_dfrbpq_1
XFILLER_37_276 VPWR VGND sg13g2_fill_1
X_8752_ _9858_/A _9260_/CLK _8752_/D place2392/X VPWR VGND sg13g2_dfrbpq_1
XFILLER_80_544 VPWR VGND sg13g2_decap_8
XFILLER_53_758 VPWR VGND sg13g2_fill_2
XFILLER_53_747 VPWR VGND sg13g2_fill_2
X_5964_ _9323_/D _5963_/B _5962_/Y _5963_/Y VPWR VGND sg13g2_o21ai_1
XFILLER_80_577 VPWR VGND sg13g2_decap_4
X_7703_ _7704_/D _9044_/Q _7767_/B _7700_/Y VPWR VGND sg13g2_o21ai_1
XFILLER_40_408 VPWR VGND sg13g2_fill_1
X_5895_ _9313_/D _9313_/Q _5920_/B _5894_/Y VPWR VGND sg13g2_a21o_1
XFILLER_52_279 VPWR VGND sg13g2_fill_1
X_8683_ _8683_/Q _9630_/CLK _8683_/D fanout943/X VPWR VGND sg13g2_dfrbpq_1
XFILLER_40_419 VPWR VGND sg13g2_fill_2
X_4915_ _4915_/Y _4999_/B _4998_/B _4914_/Y VPWR VGND sg13g2_o21ai_1
X_7634_ _7635_/B _9877_/A _7640_/A2 _7794_/B1 _8883_/Q VPWR VGND sg13g2_a22oi_1
X_4846_ _4846_/Y _4845_/Y _4983_/A _4841_/Y VPWR VGND sg13g2_a21oi_1
X_7565_ _7565_/Y _7565_/A _7565_/B _7565_/C _7565_/D VPWR VGND sg13g2_nor4_1
XFILLER_119_554 VPWR VGND sg13g2_fill_1
X_9304_ _9304_/Q _9304_/CLK _9304_/D place2407/X VPWR VGND sg13g2_dfrbpq_1
X_4777_ _4816_/B _4827_/A _4777_/B VPWR VGND sg13g2_nor2_1
XFILLER_20_187 VPWR VGND sg13g2_fill_1
X_6516_ _6516_/Y _9241_/Q _6516_/B _6516_/C _6516_/D VPWR VGND sg13g2_nand4_1
XFILLER_119_576 VPWR VGND sg13g2_decap_4
X_7496_ _7498_/B _9263_/Q _7520_/B _7533_/B1 _8876_/Q VPWR VGND sg13g2_a22oi_1
X_9235_ _9235_/Q _9242_/CLK _9235_/D place2495/X VPWR VGND sg13g2_dfrbpq_1
X_6447_ _6447_/Y _6447_/A _6510_/B VPWR VGND sg13g2_nand2_1
XFILLER_88_600 VPWR VGND sg13g2_decap_8
X_9166_ _9166_/Q clkload6/A _9166_/D place2435/X VPWR VGND sg13g2_dfrbpq_1
X_6378_ _6378_/Y _8871_/Q _6032_/Y _6377_/X _6390_/A2 VPWR VGND sg13g2_a22oi_1
X_5329_ _5329_/Y _9885_/A _5329_/B _5329_/C _5334_/C VPWR VGND sg13g2_nand4_1
X_8117_ _8117_/Y _8117_/A _8163_/B VPWR VGND sg13g2_nand2_1
XFILLER_0_559 VPWR VGND sg13g2_fill_2
X_9097_ _9097_/Q clkload8/A _9097_/D place2473/X VPWR VGND sg13g2_dfrbpq_1
XFILLER_87_165 VPWR VGND sg13g2_fill_1
XFILLER_75_305 VPWR VGND sg13g2_fill_2
XFILLER_57_69 VPWR VGND sg13g2_decap_8
X_8048_ _9031_/D _8054_/A1 _8047_/Y _8046_/Y VPWR VGND sg13g2_o21ai_1
XFILLER_75_349 VPWR VGND sg13g2_decap_8
XFILLER_28_221 VPWR VGND sg13g2_decap_4
XFILLER_56_574 VPWR VGND sg13g2_decap_4
XFILLER_28_254 VPWR VGND sg13g2_fill_2
XFILLER_29_788 VPWR VGND sg13g2_fill_1
XFILLER_71_511 VPWR VGND sg13g2_decap_8
XFILLER_16_449 VPWR VGND sg13g2_decap_8
XFILLER_24_460 VPWR VGND sg13g2_fill_1
XFILLER_12_633 VPWR VGND sg13g2_decap_8
XFILLER_12_644 VPWR VGND sg13g2_fill_2
Xinput2652 _4435_/C slave_wdata_i[7] VPWR VGND sg13g2_buf_1
Xinput2630 _7187_/B slave_wdata_i[16] VPWR VGND sg13g2_buf_1
Xinput2641 _7221_/A slave_wdata_i[26] VPWR VGND sg13g2_buf_1
XFILLER_7_136 VPWR VGND sg13g2_fill_2
XFILLER_7_158 VPWR VGND sg13g2_decap_8
XFILLER_98_32 VPWR VGND sg13g2_fill_2
XFILLER_78_110 VPWR VGND sg13g2_decap_8
XFILLER_105_281 VPWR VGND sg13g2_decap_8
XFILLER_94_603 VPWR VGND sg13g2_decap_8
XFILLER_79_644 VPWR VGND sg13g2_fill_2
XFILLER_78_121 VPWR VGND sg13g2_fill_2
XFILLER_67_806 VPWR VGND sg13g2_fill_2
XFILLER_120_262 VPWR VGND sg13g2_decap_8
XFILLER_93_146 VPWR VGND sg13g2_fill_2
XFILLER_93_135 VPWR VGND sg13g2_decap_8
XFILLER_14_7 VPWR VGND sg13g2_fill_2
XFILLER_93_168 VPWR VGND sg13g2_decap_8
XFILLER_35_736 VPWR VGND sg13g2_decap_4
XFILLER_50_706 VPWR VGND sg13g2_fill_1
XFILLER_62_599 VPWR VGND sg13g2_fill_2
X_4700_ _4701_/B _9674_/Q _4700_/B VPWR VGND sg13g2_nor2_1
XFILLER_15_482 VPWR VGND sg13g2_decap_8
X_5680_ _8593_/D _5680_/A VPWR VGND sg13g2_inv_1
X_4631_ _4633_/C _9644_/Q _9647_/Q _9646_/Q VPWR VGND sg13g2_nor3_1
XFILLER_30_496 VPWR VGND sg13g2_fill_2
Xplace2037 _6004_/B _5998_/B VPWR VGND sg13g2_buf_1
Xplace2004 _5581_/B1 _5587_/B1 VPWR VGND sg13g2_buf_1
Xplace2026 _6736_/S _6729_/S VPWR VGND sg13g2_buf_1
X_4562_ _4562_/Y _4562_/A _4562_/B _4562_/C _4562_/D VPWR VGND sg13g2_nand4_1
Xplace2015 _5439_/A1 _4387_/Y VPWR VGND sg13g2_buf_1
XFILLER_7_670 VPWR VGND sg13g2_decap_8
X_7350_ _7353_/C _7351_/C _7351_/B _8964_/Q VPWR VGND sg13g2_nor3_1
Xplace2059 _6661_/C _6672_/C VPWR VGND sg13g2_buf_1
X_4493_ _4545_/C _7245_/A _9470_/Q VPWR VGND sg13g2_nor2_1
XFILLER_7_681 VPWR VGND sg13g2_fill_2
X_7281_ _7286_/A _7275_/Y _7280_/Y _7512_/B1 VPWR VGND sg13g2_o21ai_1
X_6301_ _6301_/Y _6325_/A1 _6300_/Y _6229_/B VPWR VGND sg13g2_o21ai_1
Xplace2048 _5699_/A2 _5624_/X VPWR VGND sg13g2_buf_1
X_6232_ _6232_/Y _6415_/A1 _6512_/A2 _6232_/B1 VPWR VGND sg13g2_a21oi_1
X_9020_ _9020_/Q clkload7/A _9020_/D place2464/X VPWR VGND sg13g2_dfrbpq_1
XFILLER_103_229 VPWR VGND sg13g2_fill_2
XFILLER_103_218 VPWR VGND sg13g2_fill_1
XFILLER_112_752 VPWR VGND sg13g2_decap_8
XFILLER_69_121 VPWR VGND sg13g2_decap_4
X_6163_ _6163_/Y _9031_/Q _6077_/A _6404_/B1 _9093_/Q VPWR VGND sg13g2_a22oi_1
XFILLER_112_785 VPWR VGND sg13g2_fill_2
X_5114_ _5134_/B _9861_/A _5114_/B VPWR VGND sg13g2_nand2b_1
XFILLER_85_636 VPWR VGND sg13g2_decap_8
X_6094_ _6144_/D _9231_/Q _9233_/Q _6094_/C _6094_/D VPWR VGND sg13g2_and4_1
XFILLER_111_295 VPWR VGND sg13g2_decap_4
X_5045_ _5046_/D _5085_/D _5124_/A _5085_/C _5084_/A _5044_/Y VPWR VGND sg13g2_a221oi_1
XFILLER_69_198 VPWR VGND sg13g2_fill_2
XFILLER_72_319 VPWR VGND sg13g2_fill_1
XFILLER_38_574 VPWR VGND sg13g2_decap_8
XFILLER_25_224 VPWR VGND sg13g2_decap_8
X_6996_ _6998_/A _9305_/Q _7557_/A2 _7557_/B1 _9337_/Q VPWR VGND sg13g2_a22oi_1
XFILLER_80_352 VPWR VGND sg13g2_fill_1
X_8804_ _8804_/Q _9252_/CLK _8804_/D place2401/X VPWR VGND sg13g2_dfrbpq_1
XFILLER_53_555 VPWR VGND sg13g2_fill_1
X_5947_ _5947_/Y _5954_/A _6001_/A _5954_/C _8534_/A VPWR VGND sg13g2_nand4_1
XFILLER_80_374 VPWR VGND sg13g2_decap_8
XFILLER_80_363 VPWR VGND sg13g2_decap_8
X_8735_ _8735_/Q _9686_/CLK _8735_/D fanout962/X VPWR VGND sg13g2_dfrbpq_1
XFILLER_53_577 VPWR VGND sg13g2_decap_8
XFILLER_13_419 VPWR VGND sg13g2_decap_4
XFILLER_43_27 VPWR VGND sg13g2_decap_4
X_8666_ _8666_/Q _9630_/CLK _8666_/D fanout946/X VPWR VGND sg13g2_dfrbpq_1
X_7617_ _8914_/D _8914_/Q _7616_/Y _7774_/S VPWR VGND sg13g2_mux2_1
X_5878_ _5878_/Y _5872_/Y _5877_/X _5837_/Y VPWR VGND sg13g2_a21oi_1
X_9485__2895 _9485_/RESET_B VPWR VGND sg13g2_tiehi
X_8597_ _8597_/Q _8678_/CLK _8597_/D fanout947/X VPWR VGND sg13g2_dfrbpq_1
X_4829_ _4829_/Y _4945_/C _4828_/Y _4826_/Y VPWR VGND sg13g2_o21ai_1
XFILLER_119_373 VPWR VGND sg13g2_fill_1
XFILLER_107_502 VPWR VGND sg13g2_decap_8
X_7548_ _7548_/Y _7548_/A _7548_/B _7548_/C _7548_/D VPWR VGND sg13g2_nor4_1
XFILLER_5_629 VPWR VGND sg13g2_fill_2
X_7479_ _7479_/Y _7479_/A _7576_/S VPWR VGND sg13g2_nor2_1
XFILLER_108_42 VPWR VGND sg13g2_fill_2
XFILLER_107_557 VPWR VGND sg13g2_decap_8
X_9218_ _9218_/Q _9219_/CLK _9218_/D place2402/X VPWR VGND sg13g2_dfrbpq_1
Xplace1881 _7812_/S _7793_/S VPWR VGND sg13g2_buf_1
XFILLER_68_35 VPWR VGND sg13g2_decap_4
Xplace1870 _8458_/A _8474_/A VPWR VGND sg13g2_buf_1
Xplace1892 _6779_/S _6786_/S VPWR VGND sg13g2_buf_1
XFILLER_0_323 VPWR VGND sg13g2_decap_8
X_9149_ _9149_/Q _9153_/CLK _9149_/D place2497/X VPWR VGND sg13g2_dfrbpq_1
Xhold3240 _5426_/B1 _8668_/Q VPWR VGND sg13g2_dlygate4sd3_1
XFILLER_103_774 VPWR VGND sg13g2_fill_1
XFILLER_76_614 VPWR VGND sg13g2_decap_8
XFILLER_76_603 VPWR VGND sg13g2_fill_1
XFILLER_76_669 VPWR VGND sg13g2_decap_8
XFILLER_75_146 VPWR VGND sg13g2_decap_8
XFILLER_56_371 VPWR VGND sg13g2_decap_8
XFILLER_17_725 VPWR VGND sg13g2_decap_8
XFILLER_44_522 VPWR VGND sg13g2_decap_4
XFILLER_17_769 VPWR VGND sg13g2_fill_1
XFILLER_71_374 VPWR VGND sg13g2_decap_4
XFILLER_44_599 VPWR VGND sg13g2_decap_4
XFILLER_8_445 VPWR VGND sg13g2_decap_8
XFILLER_8_489 VPWR VGND sg13g2_decap_8
X_9530__2850 _9530_/RESET_B VPWR VGND sg13g2_tiehi
XFILLER_113_549 VPWR VGND sg13g2_decap_4
XFILLER_94_400 VPWR VGND sg13g2_fill_1
XFILLER_67_658 VPWR VGND sg13g2_decap_8
XFILLER_39_327 VPWR VGND sg13g2_fill_1
XFILLER_39_349 VPWR VGND sg13g2_decap_4
XFILLER_82_617 VPWR VGND sg13g2_fill_2
XFILLER_82_606 VPWR VGND sg13g2_decap_8
X_6850_ _9591_/D _6849_/X _9591_/Q _6906_/S VPWR VGND sg13g2_mux2_1
X_5801_ _9293_/D _5801_/A VPWR VGND sg13g2_inv_1
X_6781_ _9540_/D _9540_/Q _9450_/Q _6781_/S VPWR VGND sg13g2_mux2_1
XFILLER_50_514 VPWR VGND sg13g2_decap_8
XFILLER_23_717 VPWR VGND sg13g2_fill_2
X_5732_ _5732_/Y _5735_/A _5735_/B _9311_/Q _5735_/D VPWR VGND sg13g2_nand4_1
X_8520_ _8520_/Y _8563_/A _9489_/Q _8520_/C _8520_/D VPWR VGND sg13g2_nor4_1
XFILLER_16_791 VPWR VGND sg13g2_decap_8
XFILLER_88_0 VPWR VGND sg13g2_decap_8
XFILLER_15_290 VPWR VGND sg13g2_decap_8
XFILLER_31_761 VPWR VGND sg13g2_decap_8
X_8451_ _9230_/D _8470_/A _5344_/C _8450_/Y VPWR VGND sg13g2_o21ai_1
XFILLER_30_260 VPWR VGND sg13g2_fill_1
XFILLER_30_282 VPWR VGND sg13g2_decap_8
X_5663_ _5664_/A _5663_/A1 _5624_/X _5629_/Y _5663_/B2 VPWR VGND sg13g2_a22oi_1
X_5594_ _5594_/Y _9451_/Q _5600_/B VPWR VGND sg13g2_nand2_1
X_7402_ _7402_/Y _7402_/A _7402_/B _7402_/C VPWR VGND sg13g2_nand3_1
X_4614_ _4617_/A _9554_/Q _9553_/Q _9678_/Q _4614_/D VPWR VGND sg13g2_nor4_1
X_8382_ _9191_/D _5359_/C _8407_/A _8381_/Y VPWR VGND sg13g2_o21ai_1
X_4545_ _5400_/C _7245_/B _7245_/C _4545_/C _8498_/C VPWR VGND sg13g2_nand4_1
X_7333_ _7335_/C _7333_/A _7351_/B _8963_/Q VPWR VGND sg13g2_nor3_1
XFILLER_116_365 VPWR VGND sg13g2_fill_1
XFILLER_116_376 VPWR VGND sg13g2_decap_8
X_4476_ _4477_/B _9664_/Q _9663_/Q VPWR VGND sg13g2_nand2b_1
X_7264_ _7265_/D _6959_/B _4523_/B _6994_/Y _7264_/B2 VPWR VGND sg13g2_a22oi_1
X_9003_ _9003_/Q _9251_/CLK _9003_/D place2461/X VPWR VGND sg13g2_dfrbpq_1
XFILLER_98_750 VPWR VGND sg13g2_decap_8
X_7195_ _7195_/Y _7237_/A1 _9489_/Q _7229_/B1 _7229_/B2 VPWR VGND sg13g2_a22oi_1
X_6215_ _6215_/X _8977_/Q _9039_/Q _9101_/Q _9163_/Q _6440_/S0 _6421_/S1 VPWR VGND
+ sg13g2_mux4_1
Xfanout936 _6519_/A master_rvalid_i VPWR VGND sg13g2_buf_1
XFILLER_100_700 VPWR VGND sg13g2_fill_1
XFILLER_98_761 VPWR VGND sg13g2_fill_1
Xfanout947 fanout947/X fanout950/X VPWR VGND sg13g2_buf_1
X_6146_ _6146_/X _8967_/Q _9029_/Q _9091_/Q _9153_/Q _6381_/S0 _6381_/S1 VPWR VGND
+ sg13g2_mux4_1
Xfanout958 fanout958/X fanout959/X VPWR VGND sg13g2_buf_1
Xfanout969 fanout969/X fanout972/X VPWR VGND sg13g2_buf_1
XFILLER_100_777 VPWR VGND sg13g2_decap_8
X_6077_ _6077_/Y _6077_/A _6332_/C VPWR VGND sg13g2_nor2_1
X_5028_ _5028_/Y _5096_/C _9858_/A VPWR VGND sg13g2_nand2_1
XFILLER_26_500 VPWR VGND sg13g2_decap_4
XFILLER_26_544 VPWR VGND sg13g2_fill_2
XFILLER_26_577 VPWR VGND sg13g2_decap_8
XFILLER_41_514 VPWR VGND sg13g2_fill_1
XFILLER_81_694 VPWR VGND sg13g2_fill_2
X_6979_ _6979_/Y _6979_/A _7221_/B _7221_/C _7221_/D VPWR VGND sg13g2_nand4_1
XFILLER_13_238 VPWR VGND sg13g2_fill_2
X_9580__2810 _9580_/RESET_B VPWR VGND sg13g2_tiehi
X_8718_ _8718_/Q _9649_/CLK _8718_/D fanout976/X VPWR VGND sg13g2_dfrbpq_1
X_9698_ _9698_/Q _9708_/CLK _9698_/D fanout953/X VPWR VGND sg13g2_dfrbpq_1
X_8649_ _8649_/Q _9449_/CLK _8649_/D fanout971/X VPWR VGND sg13g2_dfrbpq_1
XFILLER_22_783 VPWR VGND sg13g2_decap_4
Xclkbuf_leaf_6_clk_i _9662_/CLK clkload2/A VPWR VGND sg13g2_buf_16
XFILLER_108_800 VPWR VGND sg13g2_fill_1
XFILLER_5_437 VPWR VGND sg13g2_decap_8
XFILLER_119_96 VPWR VGND sg13g2_decap_8
XFILLER_5_448 VPWR VGND sg13g2_fill_2
XFILLER_107_376 VPWR VGND sg13g2_fill_1
Xplace2390 place2390/X place2507/A VPWR VGND sg13g2_buf_1
XFILLER_96_709 VPWR VGND sg13g2_decap_8
XFILLER_95_208 VPWR VGND sg13g2_decap_8
XFILLER_89_783 VPWR VGND sg13g2_fill_2
Xhold3070 _8199_/A _9100_/Q VPWR VGND sg13g2_dlygate4sd3_1
XFILLER_95_33 VPWR VGND sg13g2_fill_1
Xhold3081 _8233_/A _9117_/Q VPWR VGND sg13g2_dlygate4sd3_1
Xhold3092 _5693_/B2 _8600_/Q VPWR VGND sg13g2_dlygate4sd3_1
XFILLER_48_135 VPWR VGND sg13g2_decap_4
XFILLER_76_466 VPWR VGND sg13g2_decap_8
XFILLER_76_499 VPWR VGND sg13g2_decap_4
XFILLER_28_82 VPWR VGND sg13g2_fill_1
XFILLER_13_783 VPWR VGND sg13g2_fill_2
XFILLER_8_231 VPWR VGND sg13g2_decap_8
XFILLER_60_91 VPWR VGND sg13g2_fill_1
XFILLER_113_313 VPWR VGND sg13g2_fill_1
XFILLER_99_525 VPWR VGND sg13g2_fill_2
X_4330_ _7775_/B _9885_/A VPWR VGND sg13g2_inv_1
XFILLER_5_42 VPWR VGND sg13g2_decap_8
X_6000_ _9335_/D _5999_/Y _9335_/Q _6006_/S VPWR VGND sg13g2_mux2_1
XFILLER_86_219 VPWR VGND sg13g2_decap_4
XFILLER_79_293 VPWR VGND sg13g2_decap_8
XFILLER_39_124 VPWR VGND sg13g2_fill_2
XFILLER_94_241 VPWR VGND sg13g2_fill_1
XFILLER_67_477 VPWR VGND sg13g2_decap_8
X_7951_ _7951_/Y _8092_/A _9499_/Q _7951_/C VPWR VGND sg13g2_nand3_1
X_6902_ _9617_/D _6901_/X _9617_/Q _6902_/S VPWR VGND sg13g2_mux2_1
X_7882_ _8955_/D _8955_/Q _7792_/Y _7883_/S VPWR VGND sg13g2_mux2_1
XFILLER_63_650 VPWR VGND sg13g2_decap_8
XFILLER_54_138 VPWR VGND sg13g2_decap_8
X_6833_ _9581_/D _9614_/Q _9581_/Q _6834_/S VPWR VGND sg13g2_mux2_1
X_9621_ _9621_/Q _9621_/CLK _9621_/D _9621_/RESET_B VPWR VGND sg13g2_dfrbpq_1
XFILLER_90_480 VPWR VGND sg13g2_decap_4
X_6764_ _9523_/D _9523_/Q _9433_/Q _6786_/S VPWR VGND sg13g2_mux2_1
X_9552_ _9552_/Q _9686_/CLK _9552_/D fanout964/X VPWR VGND sg13g2_dfrbpq_1
X_9483_ _9483_/Q _9603_/CLK _9483_/D _9483_/RESET_B VPWR VGND sg13g2_dfrbpq_1
X_6695_ _6714_/S _8703_/Q _4504_/A _6694_/Y VPWR VGND sg13g2_o21ai_1
X_5715_ _5715_/X _5716_/A _9312_/Q _5716_/C VPWR VGND sg13g2_and3_1
X_8503_ _8511_/B _8513_/B _8503_/B VPWR VGND sg13g2_xnor2_1
XFILLER_50_399 VPWR VGND sg13g2_decap_8
XFILLER_109_619 VPWR VGND sg13g2_fill_2
X_5646_ _5646_/Y _5646_/A _5646_/B VPWR VGND sg13g2_nor2_1
X_8434_ _8434_/Y _8444_/A _9222_/Q _8444_/C VPWR VGND sg13g2_nand3_1
X_5577_ _5577_/Y _9445_/Q _5570_/B _5580_/B1 _8647_/Q VPWR VGND sg13g2_a22oi_1
XFILLER_117_663 VPWR VGND sg13g2_fill_1
XFILLER_105_803 VPWR VGND sg13g2_fill_2
X_8365_ _8365_/Y _8367_/A _9183_/Q _8365_/C VPWR VGND sg13g2_nand3_1
XFILLER_104_313 VPWR VGND sg13g2_decap_4
X_4528_ _4528_/X _5383_/B _5826_/A VPWR VGND sg13g2_and2_1
X_8296_ _9148_/D _8350_/A1 _8029_/Y _8295_/Y VPWR VGND sg13g2_o21ai_1
X_7316_ _7316_/Y _9055_/Q _7404_/B _7386_/A VPWR VGND sg13g2_nand3b_1
XFILLER_116_195 VPWR VGND sg13g2_decap_8
X_7247_ _7247_/Y _7247_/A _9343_/Q VPWR VGND sg13g2_nor2b_1
X_4459_ _4460_/D _9694_/Q _8604_/Q VPWR VGND sg13g2_and2_1
XFILLER_77_208 VPWR VGND sg13g2_decap_8
X_7178_ _8877_/D _7177_/Y _8877_/Q _7185_/S VPWR VGND sg13g2_mux2_1
XFILLER_86_753 VPWR VGND sg13g2_decap_8
XFILLER_65_14 VPWR VGND sg13g2_decap_8
Xfanout788 _6037_/C slave_addr_i[4] VPWR VGND sg13g2_buf_1
X_6129_ _6131_/B _6129_/A _6129_/B VPWR VGND sg13g2_nand2_1
XFILLER_65_58 VPWR VGND sg13g2_decap_4
XFILLER_45_149 VPWR VGND sg13g2_fill_1
XFILLER_121_42 VPWR VGND sg13g2_decap_8
XFILLER_60_119 VPWR VGND sg13g2_decap_8
XFILLER_54_650 VPWR VGND sg13g2_decap_8
XFILLER_53_171 VPWR VGND sg13g2_fill_2
XFILLER_53_160 VPWR VGND sg13g2_decap_8
XFILLER_14_547 VPWR VGND sg13g2_decap_4
XFILLER_26_385 VPWR VGND sg13g2_decap_4
XFILLER_81_46 VPWR VGND sg13g2_fill_2
XFILLER_14_73 VPWR VGND sg13g2_decap_8
XFILLER_22_591 VPWR VGND sg13g2_decap_8
XFILLER_6_735 VPWR VGND sg13g2_fill_1
XFILLER_108_652 VPWR VGND sg13g2_fill_2
XFILLER_6_757 VPWR VGND sg13g2_fill_1
XFILLER_122_121 VPWR VGND sg13g2_decap_4
XFILLER_107_195 VPWR VGND sg13g2_decap_4
XFILLER_30_94 VPWR VGND sg13g2_fill_1
XFILLER_123_666 VPWR VGND sg13g2_decap_8
XFILLER_110_338 VPWR VGND sg13g2_fill_1
XFILLER_77_764 VPWR VGND sg13g2_fill_2
XFILLER_77_753 VPWR VGND sg13g2_fill_1
XFILLER_49_444 VPWR VGND sg13g2_decap_8
XFILLER_39_70 VPWR VGND sg13g2_fill_1
XFILLER_92_712 VPWR VGND sg13g2_fill_2
XFILLER_92_767 VPWR VGND sg13g2_decap_8
XFILLER_64_469 VPWR VGND sg13g2_fill_2
XFILLER_64_458 VPWR VGND sg13g2_fill_2
XFILLER_51_119 VPWR VGND sg13g2_decap_4
XFILLER_17_396 VPWR VGND sg13g2_decap_8
XFILLER_60_664 VPWR VGND sg13g2_decap_4
XFILLER_60_642 VPWR VGND sg13g2_fill_2
XFILLER_20_517 VPWR VGND sg13g2_fill_2
XFILLER_20_539 VPWR VGND sg13g2_decap_8
XFILLER_118_405 VPWR VGND sg13g2_fill_1
XFILLER_9_551 VPWR VGND sg13g2_decap_8
X_5500_ _5500_/Y _6541_/A _6541_/B _5500_/C VPWR VGND sg13g2_nand3_1
XFILLER_118_449 VPWR VGND sg13g2_fill_1
X_6480_ _6480_/X _9016_/Q _9078_/Q _9140_/Q _9202_/Q _6480_/S0 _6480_/S1 VPWR VGND
+ sg13g2_mux4_1
XFILLER_9_584 VPWR VGND sg13g2_decap_8
X_5431_ _5431_/Y _8672_/Q _5434_/B VPWR VGND sg13g2_nor2_1
X_5362_ _8802_/D _8563_/B _5375_/B _5362_/C _5375_/D VPWR VGND sg13g2_nor4_1
X_8150_ _9075_/D _8160_/A1 _8083_/Y _8149_/Y VPWR VGND sg13g2_o21ai_1
X_4313_ _5084_/A _9859_/A VPWR VGND sg13g2_inv_1
X_8081_ _9043_/D _8098_/A1 _8080_/Y _8079_/Y VPWR VGND sg13g2_o21ai_1
X_7101_ _8853_/D _7100_/Y _8853_/Q _7110_/S VPWR VGND sg13g2_mux2_1
X_5293_ _5293_/Y _9882_/A _5329_/B VPWR VGND sg13g2_nand2_1
X_7032_ _8407_/A _8092_/C _7032_/B _7032_/C _7032_/D VPWR VGND sg13g2_nand4_1
XFILLER_114_699 VPWR VGND sg13g2_fill_1
XFILLER_68_742 VPWR VGND sg13g2_decap_4
XFILLER_68_731 VPWR VGND sg13g2_decap_4
XFILLER_95_550 VPWR VGND sg13g2_decap_8
XFILLER_67_252 VPWR VGND sg13g2_decap_8
X_8983_ _8983_/Q clkload6/A _8983_/D place2435/X VPWR VGND sg13g2_dfrbpq_1
X_7934_ _7934_/Y _7934_/A _8979_/Q _8061_/A VPWR VGND sg13g2_nand3_1
XFILLER_35_28 VPWR VGND sg13g2_fill_1
X_7865_ _7865_/Y _9258_/Q _8513_/B _7865_/B1 VPWR VGND sg13g2_a21oi_1
XFILLER_82_299 VPWR VGND sg13g2_decap_8
XFILLER_70_439 VPWR VGND sg13g2_decap_4
XFILLER_51_631 VPWR VGND sg13g2_decap_8
XFILLER_23_322 VPWR VGND sg13g2_fill_1
X_9604_ _9604_/Q _9621_/CLK _9604_/D _9604_/RESET_B VPWR VGND sg13g2_dfrbpq_1
X_7796_ _7810_/A _9302_/Q _7796_/A2 _7796_/B1 _9334_/Q _7795_/Y VPWR VGND sg13g2_a221oi_1
X_6816_ _9564_/D _9597_/Q _9564_/Q _6840_/S VPWR VGND sg13g2_mux2_1
X_9535_ _9535_/Q _9582_/CLK _9535_/D _9535_/RESET_B VPWR VGND sg13g2_dfrbpq_1
X_6747_ _9506_/D _9506_/Q _9416_/Q _6756_/S VPWR VGND sg13g2_mux2_1
X_6678_ _6678_/Y _9456_/Q _6678_/B VPWR VGND sg13g2_nor2_1
X_9466_ _9466_/Q _9501_/CLK _9466_/D _9466_/RESET_B VPWR VGND sg13g2_dfrbpq_1
X_8417_ _9212_/D _5345_/C _8428_/A _8416_/Y VPWR VGND sg13g2_o21ai_1
X_5629_ _5629_/Y _5629_/A _5629_/B _5629_/C _6915_/A VPWR VGND sg13g2_nand4_1
X_9397_ _9397_/Q _9406_/CLK _9397_/D place2489/X VPWR VGND sg13g2_dfrbpq_1
XFILLER_105_611 VPWR VGND sg13g2_fill_2
XFILLER_105_600 VPWR VGND sg13g2_fill_2
X_8348_ _9174_/D _7028_/D _7954_/Y _8347_/Y VPWR VGND sg13g2_o21ai_1
XFILLER_105_622 VPWR VGND sg13g2_fill_1
X_8279_ _8279_/Y _8279_/A _8279_/B VPWR VGND sg13g2_nand2_1
XFILLER_104_176 VPWR VGND sg13g2_fill_1
XFILLER_86_572 VPWR VGND sg13g2_decap_8
XFILLER_59_786 VPWR VGND sg13g2_fill_1
XFILLER_92_12 VPWR VGND sg13g2_fill_2
Xclkbuf_leaf_24_clk_i clkload9/A clkbuf_3_2__f_clk_i/X VPWR VGND sg13g2_buf_16
XFILLER_15_801 VPWR VGND sg13g2_decap_8
XFILLER_27_650 VPWR VGND sg13g2_decap_8
XFILLER_73_288 VPWR VGND sg13g2_fill_1
XFILLER_61_428 VPWR VGND sg13g2_fill_2
XFILLER_26_193 VPWR VGND sg13g2_fill_1
XFILLER_42_664 VPWR VGND sg13g2_decap_8
X_9498__2882 _9498_/RESET_B VPWR VGND sg13g2_tiehi
XFILLER_110_102 VPWR VGND sg13g2_fill_2
XFILLER_2_21 VPWR VGND sg13g2_decap_8
XFILLER_49_263 VPWR VGND sg13g2_fill_2
X_5980_ _5980_/Y _9494_/Q _5980_/A2 _5889_/X _5980_/B2 VPWR VGND sg13g2_a22oi_1
XFILLER_92_575 VPWR VGND sg13g2_fill_1
XFILLER_92_564 VPWR VGND sg13g2_decap_8
XFILLER_64_244 VPWR VGND sg13g2_fill_2
XFILLER_18_694 VPWR VGND sg13g2_decap_4
XFILLER_24_119 VPWR VGND sg13g2_decap_8
X_4931_ _4931_/Y _4927_/Y _4931_/B VPWR VGND sg13g2_nand2b_1
X_7650_ _7652_/B _7651_/A _9134_/Q _7650_/C VPWR VGND sg13g2_nor3_1
X_4862_ _4862_/Y _4816_/A _4791_/C _4834_/B _4856_/Y _4899_/C VPWR VGND sg13g2_a221oi_1
X_6601_ _6601_/Y _6661_/C _8634_/Q _9566_/Q _6669_/B2 VPWR VGND sg13g2_a22oi_1
X_9320_ _9320_/Q _9410_/CLK _9320_/D place2397/X VPWR VGND sg13g2_dfrbpq_1
X_7581_ _7581_/Y _7581_/A _7581_/B _7581_/C VPWR VGND sg13g2_nand3_1
X_4793_ _4924_/B _4827_/A _4793_/B VPWR VGND sg13g2_nand2_1
X_6532_ _6532_/Y _5038_/Y _6524_/A _6534_/D VPWR VGND sg13g2_a21oi_1
XFILLER_70_0 VPWR VGND sg13g2_decap_8
XFILLER_9_370 VPWR VGND sg13g2_decap_4
X_6463_ _6463_/Y _6504_/A1 _6463_/A2 _6463_/B1 VPWR VGND sg13g2_a21oi_1
XFILLER_9_392 VPWR VGND sg13g2_decap_4
X_9251_ _9251_/Q _9251_/CLK _9251_/D place2478/X VPWR VGND sg13g2_dfrbpq_1
X_8202_ _9101_/D _8222_/A1 _8068_/Y _8201_/Y VPWR VGND sg13g2_o21ai_1
X_5414_ _5415_/A _5414_/A _5414_/B _8448_/C VPWR VGND sg13g2_nand3_1
X_9182_ _9182_/Q clkload8/A _9182_/D place2466/X VPWR VGND sg13g2_dfrbpq_1
X_8133_ _8133_/Y _8133_/A _8157_/B VPWR VGND sg13g2_nand2_1
X_6394_ _6394_/Y _8875_/Q _7176_/B2 _6393_/X _6401_/B2 VPWR VGND sg13g2_a22oi_1
X_5345_ _8785_/D _5360_/A _5360_/B _5345_/C _5360_/D VPWR VGND sg13g2_nor4_1
XFILLER_87_336 VPWR VGND sg13g2_fill_1
X_5276_ _5276_/Y _9878_/A _9879_/A _5291_/B _5291_/C VPWR VGND sg13g2_nand4_1
X_8064_ _9037_/D _8102_/A1 _7925_/Y _8063_/Y VPWR VGND sg13g2_o21ai_1
XFILLER_102_658 VPWR VGND sg13g2_fill_2
X_7015_ _8827_/D _8098_/A1 _7008_/Y _7014_/Y VPWR VGND sg13g2_o21ai_1
Xhold2924 _8737_/D _8736_/Q VPWR VGND sg13g2_dlygate4sd3_1
Xhold2935 _8726_/D _8725_/Q VPWR VGND sg13g2_dlygate4sd3_1
Xhold2946 _6313_/B1 _9372_/Q VPWR VGND sg13g2_dlygate4sd3_1
Xhold2957 _6423_/B1 _9392_/Q VPWR VGND sg13g2_dlygate4sd3_1
Xhold2968 _6457_/B1 _9398_/Q VPWR VGND sg13g2_dlygate4sd3_1
Xhold2979 _8613_/D _5643_/Y VPWR VGND sg13g2_dlygate4sd3_1
XFILLER_46_27 VPWR VGND sg13g2_decap_4
XFILLER_46_38 VPWR VGND sg13g2_fill_2
XFILLER_46_49 VPWR VGND sg13g2_fill_1
XFILLER_55_255 VPWR VGND sg13g2_decap_4
XFILLER_16_609 VPWR VGND sg13g2_fill_1
X_8966_ _8966_/Q _9183_/CLK _8966_/D place2471/X VPWR VGND sg13g2_dfrbpq_1
XFILLER_71_759 VPWR VGND sg13g2_decap_4
X_7917_ _7917_/Y _7917_/A _8972_/Q _8409_/C VPWR VGND sg13g2_nand3_1
X_8897_ _8897_/Q _9620_/CLK _8897_/D place2429/X VPWR VGND sg13g2_dfrbpq_1
XFILLER_70_269 VPWR VGND sg13g2_fill_1
XFILLER_70_247 VPWR VGND sg13g2_fill_2
XFILLER_62_15 VPWR VGND sg13g2_decap_4
X_7848_ _8926_/D _8926_/Q _7847_/Y _7848_/S VPWR VGND sg13g2_mux2_1
XFILLER_11_314 VPWR VGND sg13g2_decap_8
XFILLER_23_163 VPWR VGND sg13g2_fill_1
X_7779_ _7780_/D _9203_/Q _7724_/B _7785_/A VPWR VGND sg13g2_o21ai_1
X_9518_ _9518_/Q _9686_/CLK _9518_/D _9518_/RESET_B VPWR VGND sg13g2_dfrbpq_1
XFILLER_109_246 VPWR VGND sg13g2_decap_8
XFILLER_109_235 VPWR VGND sg13g2_decap_8
X_9449_ _9449_/Q _9449_/CLK _9449_/D fanout981/X VPWR VGND sg13g2_dfrbpq_1
XFILLER_11_30 VPWR VGND sg13g2_decap_8
XFILLER_79_804 VPWR VGND sg13g2_fill_1
XFILLER_120_455 VPWR VGND sg13g2_decap_8
XFILLER_120_433 VPWR VGND sg13g2_fill_2
XFILLER_87_78 VPWR VGND sg13g2_decap_4
XFILLER_78_358 VPWR VGND sg13g2_decap_8
XFILLER_101_691 VPWR VGND sg13g2_decap_8
XFILLER_93_339 VPWR VGND sg13g2_decap_4
XFILLER_86_380 VPWR VGND sg13g2_fill_2
XFILLER_74_553 VPWR VGND sg13g2_fill_2
XFILLER_15_620 VPWR VGND sg13g2_fill_2
XFILLER_34_439 VPWR VGND sg13g2_decap_8
XFILLER_15_642 VPWR VGND sg13g2_decap_8
XFILLER_36_93 VPWR VGND sg13g2_fill_1
XFILLER_15_686 VPWR VGND sg13g2_decap_8
XFILLER_30_645 VPWR VGND sg13g2_decap_4
XFILLER_52_81 VPWR VGND sg13g2_fill_2
Xplace2219 _7811_/A _9504_/Q VPWR VGND sg13g2_buf_1
Xplace2208 _6566_/A _9635_/Q VPWR VGND sg13g2_buf_1
XFILLER_97_612 VPWR VGND sg13g2_decap_4
X_5130_ _5192_/A _9862_/A _5130_/B VPWR VGND sg13g2_xnor2_1
XFILLER_123_282 VPWR VGND sg13g2_decap_4
XFILLER_97_645 VPWR VGND sg13g2_decap_8
X_5061_ _5124_/B _5123_/A _9262_/Q VPWR VGND sg13g2_nand2_1
XFILLER_37_200 VPWR VGND sg13g2_decap_8
XFILLER_38_734 VPWR VGND sg13g2_fill_2
X_8820_ _8820_/Q _9414_/CLK _8820_/D place2500/X VPWR VGND sg13g2_dfrbpq_1
XFILLER_38_789 VPWR VGND sg13g2_fill_2
X_5963_ _5963_/Y _9323_/Q _5963_/B VPWR VGND sg13g2_nand2_1
X_8751_ _8751_/Q _9305_/CLK _8751_/D place2404/X VPWR VGND sg13g2_dfrbpq_1
XFILLER_80_523 VPWR VGND sg13g2_decap_8
XFILLER_65_597 VPWR VGND sg13g2_fill_1
XFILLER_52_203 VPWR VGND sg13g2_fill_1
X_7702_ _7704_/C _7705_/A _7705_/B _8982_/Q VPWR VGND sg13g2_nor3_1
XFILLER_18_491 VPWR VGND sg13g2_decap_8
X_4914_ _4914_/Y _4914_/A _4914_/B VPWR VGND sg13g2_nor2_1
X_5894_ _5894_/Y _5888_/Y _5893_/X _5837_/Y VPWR VGND sg13g2_a21oi_1
XFILLER_61_781 VPWR VGND sg13g2_fill_1
XFILLER_52_269 VPWR VGND sg13g2_fill_2
X_8682_ _8682_/Q _9630_/CLK _8682_/D fanout943/X VPWR VGND sg13g2_dfrbpq_1
X_7633_ _7635_/A _5132_/B _7520_/B _7809_/B1 _7633_/B2 VPWR VGND sg13g2_a22oi_1
X_4845_ _4845_/Y _4939_/A2 _4761_/X _4844_/Y _4782_/D VPWR VGND sg13g2_a22oi_1
XFILLER_33_494 VPWR VGND sg13g2_decap_8
X_4776_ _4777_/B _4820_/B _4776_/B VPWR VGND sg13g2_nand2_1
X_7564_ _7565_/C _7834_/A _9130_/Q _7832_/C VPWR VGND sg13g2_nor3_1
X_9303_ _9303_/Q _9304_/CLK _9303_/D place2410/X VPWR VGND sg13g2_dfrbpq_1
X_6515_ _6515_/Y _8822_/Q _7237_/B2 _6515_/B1 _6514_/X VPWR VGND sg13g2_a22oi_1
XFILLER_20_199 VPWR VGND sg13g2_decap_8
X_7495_ _7498_/A _7489_/Y _7494_/Y _7512_/B1 VPWR VGND sg13g2_o21ai_1
X_9234_ _9234_/Q _9242_/CLK _9234_/D place2494/X VPWR VGND sg13g2_dfrbpq_1
X_6446_ _6447_/A _9231_/Q _6509_/D _6509_/C _6509_/B VPWR VGND sg13g2_nand4_1
X_9165_ _9165_/Q _9254_/CLK _9165_/D place2453/X VPWR VGND sg13g2_dfrbpq_1
X_6377_ _6377_/X _8997_/Q _9059_/Q _9121_/Q _9183_/Q _6377_/S0 _6381_/S1 VPWR VGND
+ sg13g2_mux4_1
XFILLER_88_634 VPWR VGND sg13g2_decap_8
X_5328_ _5330_/B _5334_/A _5334_/B _9886_/A _9887_/A VPWR VGND sg13g2_nand4_1
XFILLER_0_505 VPWR VGND sg13g2_fill_2
X_8116_ _9058_/D _8120_/A1 _7902_/Y _8115_/Y VPWR VGND sg13g2_o21ai_1
X_9096_ _9096_/Q clkload8/A _9096_/D place2475/X VPWR VGND sg13g2_dfrbpq_1
XFILLER_102_433 VPWR VGND sg13g2_fill_2
X_8047_ _8047_/Y _8391_/C _9481_/Q _8056_/C _8068_/D VPWR VGND sg13g2_nand4_1
XFILLER_88_689 VPWR VGND sg13g2_decap_8
XFILLER_87_177 VPWR VGND sg13g2_fill_2
X_5259_ _5290_/C _9874_/A _9875_/A _9876_/A _9877_/A VPWR VGND sg13g2_and4_1
XFILLER_75_328 VPWR VGND sg13g2_decap_8
XFILLER_83_350 VPWR VGND sg13g2_decap_4
XFILLER_56_553 VPWR VGND sg13g2_decap_8
XFILLER_29_767 VPWR VGND sg13g2_decap_4
XFILLER_56_586 VPWR VGND sg13g2_fill_2
XFILLER_16_428 VPWR VGND sg13g2_fill_2
X_8949_ _8949_/Q _9615_/CLK _8949_/D place2416/X VPWR VGND sg13g2_dfrbpq_1
XFILLER_73_58 VPWR VGND sg13g2_decap_4
XFILLER_51_280 VPWR VGND sg13g2_fill_1
XFILLER_8_627 VPWR VGND sg13g2_decap_8
XFILLER_8_616 VPWR VGND sg13g2_fill_1
Xinput2620 _6538_/A1 slave_aid_i[2] VPWR VGND sg13g2_buf_1
XFILLER_12_689 VPWR VGND sg13g2_decap_4
Xinput2642 _7224_/B slave_wdata_i[27] VPWR VGND sg13g2_buf_1
Xinput2631 _7191_/A slave_wdata_i[17] VPWR VGND sg13g2_buf_1
XFILLER_11_188 VPWR VGND sg13g2_fill_1
XFILLER_11_166 VPWR VGND sg13g2_fill_2
Xinput2653 _7158_/A slave_wdata_i[8] VPWR VGND sg13g2_buf_1
XFILLER_118_0 VPWR VGND sg13g2_decap_8
XFILLER_98_11 VPWR VGND sg13g2_decap_4
XFILLER_3_354 VPWR VGND sg13g2_fill_2
XFILLER_105_271 VPWR VGND sg13g2_decap_4
XFILLER_0_0 VPWR VGND sg13g2_decap_8
XFILLER_78_144 VPWR VGND sg13g2_fill_1
XFILLER_120_241 VPWR VGND sg13g2_decap_8
XFILLER_66_339 VPWR VGND sg13g2_fill_2
XFILLER_66_328 VPWR VGND sg13g2_decap_8
XFILLER_19_211 VPWR VGND sg13g2_fill_1
XFILLER_47_586 VPWR VGND sg13g2_fill_2
XFILLER_47_575 VPWR VGND sg13g2_decap_8
XFILLER_19_288 VPWR VGND sg13g2_fill_1
XFILLER_34_214 VPWR VGND sg13g2_fill_1
XFILLER_35_748 VPWR VGND sg13g2_fill_2
XFILLER_62_567 VPWR VGND sg13g2_decap_8
XFILLER_63_80 VPWR VGND sg13g2_decap_8
XFILLER_15_494 VPWR VGND sg13g2_decap_8
X_4630_ _4633_/B _9457_/Q _4652_/A _9458_/Q VPWR VGND sg13g2_nand3b_1
XFILLER_8_42 VPWR VGND sg13g2_decap_8
XFILLER_8_53 VPWR VGND sg13g2_fill_1
Xplace2027 _6726_/S _6729_/S VPWR VGND sg13g2_buf_1
Xplace2005 _5587_/B1 _5593_/B1 VPWR VGND sg13g2_buf_1
X_4561_ _4562_/C _4557_/Y _4554_/Y _4560_/Y VPWR VGND sg13g2_a21o_1
Xplace2016 _5455_/A1 _5469_/A1 VPWR VGND sg13g2_buf_1
X_6300_ _6300_/Y _6248_/C _6298_/Y _6299_/Y VPWR VGND sg13g2_a21oi_1
Xplace2038 _8222_/A1 _8226_/A1 VPWR VGND sg13g2_buf_1
X_4492_ _4512_/B _9502_/Q _9501_/Q VPWR VGND sg13g2_nand2b_1
X_7280_ _7280_/Y _7299_/A _7280_/B _7280_/C _7280_/D VPWR VGND sg13g2_nor4_1
Xplace2049 _5693_/A2 _5677_/A2 VPWR VGND sg13g2_buf_1
XFILLER_116_558 VPWR VGND sg13g2_decap_8
X_6231_ _6231_/Y _8853_/Q _6441_/A2 _6230_/X _6434_/A2 _6484_/S VPWR VGND sg13g2_a221oi_1
X_6162_ _6162_/Y _8969_/Q _6410_/A _6173_/A _9155_/Q VPWR VGND sg13g2_a22oi_1
X_5113_ _5118_/A _8528_/B _5112_/Y _9861_/A VPWR VGND sg13g2_a21oi_1
XFILLER_33_0 VPWR VGND sg13g2_fill_2
X_6093_ _6094_/D _9230_/Q _9232_/Q VPWR VGND sg13g2_nor2_1
X_5044_ _5044_/Y _5123_/B _9859_/A _5086_/B _5085_/D VPWR VGND sg13g2_nor4_1
XFILLER_93_670 VPWR VGND sg13g2_decap_8
X_8803_ _8803_/Q _9219_/CLK _8803_/D place2408/X VPWR VGND sg13g2_dfrbpq_1
XFILLER_25_203 VPWR VGND sg13g2_decap_8
XFILLER_26_737 VPWR VGND sg13g2_decap_4
XFILLER_38_597 VPWR VGND sg13g2_decap_8
XFILLER_80_320 VPWR VGND sg13g2_fill_2
X_6995_ _6998_/C _7831_/A _8822_/Q _7831_/C VPWR VGND sg13g2_nand3_1
XFILLER_53_545 VPWR VGND sg13g2_fill_1
XFILLER_25_236 VPWR VGND sg13g2_decap_8
X_5946_ _5946_/Y _5932_/D _5932_/B _5929_/B _5946_/B2 VPWR VGND sg13g2_a22oi_1
XFILLER_34_770 VPWR VGND sg13g2_decap_4
X_8734_ _8734_/Q _9689_/CLK _8734_/D fanout962/X VPWR VGND sg13g2_dfrbpq_1
X_5877_ _5877_/X _5874_/Y _5875_/Y _5876_/Y VPWR VGND sg13g2_a21o_1
X_8665_ _8665_/Q _9701_/CLK _8665_/D fanout951/X VPWR VGND sg13g2_dfrbpq_1
X_7616_ _7616_/Y _7829_/A _7616_/B VPWR VGND sg13g2_nor2_1
XFILLER_21_442 VPWR VGND sg13g2_fill_2
X_4828_ _4828_/Y _4880_/D _4898_/C VPWR VGND sg13g2_nand2_1
X_8596_ _8596_/Q _8678_/CLK _8596_/D fanout947/X VPWR VGND sg13g2_dfrbpq_1
X_7547_ _7548_/B _9191_/Q _7724_/B _7785_/A VPWR VGND sg13g2_o21ai_1
X_4759_ _4924_/A _4923_/A _4827_/A VPWR VGND sg13g2_nand2b_1
X_7478_ _8907_/D _8907_/Q _7477_/Y _7830_/S VPWR VGND sg13g2_mux2_1
X_9217_ _9217_/Q _9254_/CLK _9217_/D place2409/X VPWR VGND sg13g2_dfrbpq_1
X_6429_ _6429_/X _9008_/Q _9070_/Q _9132_/Q _9194_/Q _6440_/S0 _6440_/S1 VPWR VGND
+ sg13g2_mux4_1
Xplace1860 _5960_/B _6003_/S VPWR VGND sg13g2_buf_1
XFILLER_68_14 VPWR VGND sg13g2_decap_4
Xplace1871 _8474_/A _8492_/A VPWR VGND sg13g2_buf_1
Xhold3241 _6774_/A1 _9443_/Q VPWR VGND sg13g2_dlygate4sd3_1
XFILLER_108_98 VPWR VGND sg13g2_decap_8
XFILLER_103_742 VPWR VGND sg13g2_fill_1
Xplace1893 _6786_/S _6785_/S VPWR VGND sg13g2_buf_1
Xhold3230 _5615_/A _9419_/Q VPWR VGND sg13g2_dlygate4sd3_1
XFILLER_0_313 VPWR VGND sg13g2_decap_4
X_9148_ _9148_/Q _9183_/CLK _9148_/D place2469/X VPWR VGND sg13g2_dfrbpq_1
Xplace1882 _7222_/A2 _6978_/Y VPWR VGND sg13g2_buf_1
XFILLER_103_764 VPWR VGND sg13g2_decap_4
X_9079_ _9079_/Q _9198_/CLK _9079_/D place2436/X VPWR VGND sg13g2_dfrbpq_1
XFILLER_48_306 VPWR VGND sg13g2_decap_4
XFILLER_76_648 VPWR VGND sg13g2_decap_8
XFILLER_91_618 VPWR VGND sg13g2_decap_8
XFILLER_84_35 VPWR VGND sg13g2_decap_8
XFILLER_84_692 VPWR VGND sg13g2_decap_8
XFILLER_84_681 VPWR VGND sg13g2_decap_8
XFILLER_44_501 VPWR VGND sg13g2_decap_8
XFILLER_16_225 VPWR VGND sg13g2_fill_2
XFILLER_44_556 VPWR VGND sg13g2_decap_8
X_9612__2778 _9612_/RESET_B VPWR VGND sg13g2_tiehi
XFILLER_31_217 VPWR VGND sg13g2_decap_8
XFILLER_32_729 VPWR VGND sg13g2_decap_8
XFILLER_12_420 VPWR VGND sg13g2_decap_8
XFILLER_31_228 VPWR VGND sg13g2_fill_2
XFILLER_12_453 VPWR VGND sg13g2_decap_8
XFILLER_12_475 VPWR VGND sg13g2_decap_8
XFILLER_4_663 VPWR VGND sg13g2_decap_8
XFILLER_121_550 VPWR VGND sg13g2_fill_2
XFILLER_79_453 VPWR VGND sg13g2_decap_8
XFILLER_39_306 VPWR VGND sg13g2_fill_2
XFILLER_67_637 VPWR VGND sg13g2_decap_8
X_5800_ _5801_/A _9293_/Q _8579_/A2 _8579_/B1 _9490_/Q VPWR VGND sg13g2_a22oi_1
X_6780_ _9539_/D _9539_/Q _9449_/Q _6781_/S VPWR VGND sg13g2_mux2_1
XFILLER_16_770 VPWR VGND sg13g2_decap_8
XFILLER_35_589 VPWR VGND sg13g2_fill_1
X_5731_ _5731_/Y _5762_/A1 _5740_/A2 _5729_/Y _5730_/Y VPWR VGND sg13g2_a22oi_1
X_8450_ _8450_/Y _8470_/A _9230_/Q _8474_/C VPWR VGND sg13g2_nand3_1
X_5662_ _8607_/D _5662_/A _5662_/B VPWR VGND sg13g2_nor2_1
X_7401_ _7402_/C _9282_/Q _7796_/A2 _7796_/B1 _9314_/Q VPWR VGND sg13g2_a22oi_1
X_5593_ _8652_/D _5592_/Y _5591_/Y _5593_/B1 VPWR VGND sg13g2_a21oi_1
X_4613_ _4613_/Y _9553_/Q _9678_/Q _4614_/D VPWR VGND sg13g2_nor3_1
X_8381_ _8381_/Y _8397_/A _9191_/Q _8407_/C VPWR VGND sg13g2_nand3_1
XFILLER_116_322 VPWR VGND sg13g2_decap_8
XFILLER_116_311 VPWR VGND sg13g2_fill_1
X_4544_ _8413_/B _7245_/B _7245_/C _4545_/C _8498_/C VPWR VGND sg13g2_and4_1
X_7332_ _7335_/B _7333_/A _8994_/Q _7387_/C VPWR VGND sg13g2_nor3_1
X_7263_ _7265_/C _9221_/Q _7520_/B _7533_/B1 _8864_/Q VPWR VGND sg13g2_a22oi_1
XFILLER_116_388 VPWR VGND sg13g2_decap_8
XFILLER_104_517 VPWR VGND sg13g2_fill_2
XFILLER_104_506 VPWR VGND sg13g2_decap_8
XFILLER_89_206 VPWR VGND sg13g2_decap_4
X_4475_ _9666_/D _4708_/A _4475_/B VPWR VGND sg13g2_nor2_1
X_6214_ _9361_/D _6505_/A2 _6212_/Y _6213_/Y VPWR VGND sg13g2_a21oi_1
X_9002_ _9002_/Q clkload4/A _9002_/D place2481/X VPWR VGND sg13g2_dfrbpq_1
XFILLER_89_239 VPWR VGND sg13g2_decap_4
X_7194_ _7194_/Y _7236_/A _7194_/B _7236_/C _7207_/B VPWR VGND sg13g2_nand4_1
Xfanout937 _8528_/C _8530_/D VPWR VGND sg13g2_buf_1
X_6145_ _6145_/Y _6410_/A _6145_/B _6145_/C VPWR VGND sg13g2_nor3_1
Xfanout948 fanout948/X fanout950/X VPWR VGND sg13g2_buf_1
XFILLER_112_572 VPWR VGND sg13g2_decap_8
XFILLER_58_659 VPWR VGND sg13g2_decap_8
XFILLER_58_637 VPWR VGND sg13g2_decap_8
X_6076_ _6080_/B _6397_/B _6369_/A _6153_/D VPWR VGND sg13g2_nand3_1
Xfanout959 fanout959/X fanout960/X VPWR VGND sg13g2_buf_1
X_5027_ _5083_/A _9261_/Q _5085_/D VPWR VGND sg13g2_nor2_1
XFILLER_81_673 VPWR VGND sg13g2_decap_8
XFILLER_14_729 VPWR VGND sg13g2_fill_2
X_8717_ _8717_/Q _9649_/CLK _8717_/D fanout975/X VPWR VGND sg13g2_dfrbpq_1
XFILLER_53_397 VPWR VGND sg13g2_fill_2
X_6978_ _6978_/Y _7132_/D _7818_/B VPWR VGND sg13g2_nand2_1
X_5929_ _5929_/Y _5929_/A _5929_/B VPWR VGND sg13g2_nor2_1
X_9697_ _9697_/Q _9701_/CLK _9697_/D fanout951/X VPWR VGND sg13g2_dfrbpq_1
X_8648_ _8648_/Q _9449_/CLK _8648_/D fanout971/X VPWR VGND sg13g2_dfrbpq_1
XFILLER_21_250 VPWR VGND sg13g2_fill_2
X_8579_ _8580_/A _9282_/Q _8579_/A2 _8579_/B1 _9479_/Q VPWR VGND sg13g2_a22oi_1
XFILLER_119_42 VPWR VGND sg13g2_fill_2
XFILLER_119_193 VPWR VGND sg13g2_decap_8
XFILLER_119_75 VPWR VGND sg13g2_decap_8
XFILLER_79_57 VPWR VGND sg13g2_fill_1
Xplace2391 place2391/X place2400/X VPWR VGND sg13g2_buf_1
Xplace2380 _8355_/C _5203_/A VPWR VGND sg13g2_buf_1
XFILLER_122_369 VPWR VGND sg13g2_fill_1
Xhold3060 _8211_/A _9106_/Q VPWR VGND sg13g2_dlygate4sd3_1
XFILLER_88_272 VPWR VGND sg13g2_decap_8
Xhold3071 _4593_/B _9707_/Q VPWR VGND sg13g2_dlygate4sd3_1
Xhold3082 _8243_/A _9122_/Q VPWR VGND sg13g2_dlygate4sd3_1
Xhold3093 _5663_/B2 _8608_/Q VPWR VGND sg13g2_dlygate4sd3_1
XFILLER_95_78 VPWR VGND sg13g2_fill_2
XFILLER_76_445 VPWR VGND sg13g2_fill_2
XFILLER_91_415 VPWR VGND sg13g2_fill_2
XFILLER_64_629 VPWR VGND sg13g2_decap_8
XFILLER_28_61 VPWR VGND sg13g2_decap_8
XFILLER_91_448 VPWR VGND sg13g2_fill_1
XFILLER_17_578 VPWR VGND sg13g2_fill_2
XFILLER_9_744 VPWR VGND sg13g2_decap_8
XFILLER_118_609 VPWR VGND sg13g2_decap_4
XFILLER_117_108 VPWR VGND sg13g2_fill_2
XFILLER_5_21 VPWR VGND sg13g2_decap_8
XFILLER_95_710 VPWR VGND sg13g2_decap_8
XFILLER_79_283 VPWR VGND sg13g2_fill_1
XFILLER_39_103 VPWR VGND sg13g2_decap_8
XFILLER_95_754 VPWR VGND sg13g2_fill_1
X_7950_ _7950_/Y _7950_/A _7950_/B _8089_/A VPWR VGND sg13g2_nand3_1
X_7881_ _8954_/D _8954_/Q _7773_/Y _7881_/S VPWR VGND sg13g2_mux2_1
X_6901_ _6901_/X _8924_/Q _8956_/Q _6901_/S VPWR VGND sg13g2_mux2_1
XFILLER_35_331 VPWR VGND sg13g2_decap_4
X_6832_ _9580_/D _9613_/Q _9580_/Q _6840_/S VPWR VGND sg13g2_mux2_1
X_9620_ _9620_/Q _9620_/CLK _9620_/D _9620_/RESET_B VPWR VGND sg13g2_dfrbpq_1
XFILLER_35_364 VPWR VGND sg13g2_decap_8
XFILLER_63_695 VPWR VGND sg13g2_decap_8
XFILLER_62_172 VPWR VGND sg13g2_fill_2
XFILLER_50_301 VPWR VGND sg13g2_decap_8
XFILLER_23_548 VPWR VGND sg13g2_decap_4
XFILLER_35_386 VPWR VGND sg13g2_decap_8
XFILLER_35_397 VPWR VGND sg13g2_fill_1
X_6763_ _9522_/D _9522_/Q _9432_/Q _6786_/S VPWR VGND sg13g2_mux2_1
X_9551_ _9551_/Q _9686_/CLK _9551_/D fanout964/X VPWR VGND sg13g2_dfrbpq_1
X_6694_ _6694_/Y _8704_/Q _9463_/Q _8703_/Q VPWR VGND sg13g2_o21ai_1
X_9482_ _9482_/Q _9603_/CLK _9482_/D _9482_/RESET_B VPWR VGND sg13g2_dfrbpq_1
X_5714_ _5714_/X _5716_/A _9311_/Q _5716_/C VPWR VGND sg13g2_and3_1
X_8502_ _9255_/D _8744_/Q _8502_/B _8502_/C VPWR VGND sg13g2_nor3_1
X_8433_ _9220_/D _5367_/C _8432_/A _8432_/Y VPWR VGND sg13g2_o21ai_1
X_5645_ _5646_/B _4457_/X _5629_/A _5645_/B1 VPWR VGND sg13g2_a21oi_1
X_5576_ _5576_/Y _5585_/A _5585_/B _8648_/Q _5585_/D VPWR VGND sg13g2_nand4_1
X_8364_ _9182_/D _5350_/C _8367_/A _8363_/Y VPWR VGND sg13g2_o21ai_1
X_4527_ _4562_/D _8747_/Q _8746_/Q _8748_/Q _6309_/A VPWR VGND sg13g2_nor4_1
X_7315_ _7318_/C _7386_/A _7351_/B _8962_/Q VPWR VGND sg13g2_nor3_1
X_8295_ _8295_/Y _9148_/Q _8349_/B VPWR VGND sg13g2_nand2_1
XFILLER_116_185 VPWR VGND sg13g2_decap_4
X_7246_ _7247_/A _7269_/A _7016_/Y _7245_/Y _8498_/C _7244_/Y VPWR VGND sg13g2_a221oi_1
X_4458_ _4458_/X _6915_/A _9694_/Q _5629_/C _5629_/B VPWR VGND sg13g2_and4_1
XFILLER_49_38 VPWR VGND sg13g2_decap_8
X_7177_ _7177_/Y _6959_/Y _7175_/Y _7176_/Y VPWR VGND sg13g2_a21oi_1
XFILLER_100_520 VPWR VGND sg13g2_fill_2
X_4389_ _5434_/B _4591_/B _4389_/B VPWR VGND sg13g2_nand2_1
X_6128_ _6129_/B _8965_/Q _9027_/Q _9089_/Q _9151_/Q _6381_/S0 _6381_/S1 VPWR VGND
+ sg13g2_mux4_1
Xfanout767 _7218_/B slave_be_i[3] VPWR VGND sg13g2_buf_1
XFILLER_85_231 VPWR VGND sg13g2_decap_8
XFILLER_105_77 VPWR VGND sg13g2_fill_2
XFILLER_73_426 VPWR VGND sg13g2_fill_2
XFILLER_73_415 VPWR VGND sg13g2_decap_8
X_6059_ _6077_/A _6158_/A _6451_/A VPWR VGND sg13g2_nor2_1
XFILLER_45_117 VPWR VGND sg13g2_decap_8
XFILLER_46_629 VPWR VGND sg13g2_decap_4
XFILLER_39_692 VPWR VGND sg13g2_fill_1
XFILLER_121_21 VPWR VGND sg13g2_decap_8
XFILLER_54_673 VPWR VGND sg13g2_decap_8
XFILLER_41_323 VPWR VGND sg13g2_decap_8
X_9521__2859 _9521_/RESET_B VPWR VGND sg13g2_tiehi
XFILLER_14_52 VPWR VGND sg13g2_decap_8
XFILLER_41_389 VPWR VGND sg13g2_decap_4
XFILLER_10_743 VPWR VGND sg13g2_decap_8
XFILLER_6_725 VPWR VGND sg13g2_fill_1
XFILLER_100_0 VPWR VGND sg13g2_decap_8
XFILLER_123_645 VPWR VGND sg13g2_decap_8
XFILLER_96_518 VPWR VGND sg13g2_fill_2
XFILLER_122_177 VPWR VGND sg13g2_fill_2
XFILLER_89_570 VPWR VGND sg13g2_decap_4
XFILLER_17_331 VPWR VGND sg13g2_fill_2
XFILLER_44_150 VPWR VGND sg13g2_decap_4
XFILLER_13_592 VPWR VGND sg13g2_fill_2
X_5430_ _8668_/D _5430_/A _5472_/B_N VPWR VGND sg13g2_nor2b_1
X_5361_ _8801_/D _8563_/B _5836_/C _5361_/C _5372_/D VPWR VGND sg13g2_nor4_1
X_4312_ _5085_/C _9858_/A VPWR VGND sg13g2_inv_1
X_5292_ _5295_/A _5291_/Y _5315_/B _7729_/B VPWR VGND sg13g2_o21ai_1
X_8080_ _8080_/Y _8089_/A _9493_/Q _8092_/C _8095_/D VPWR VGND sg13g2_nand4_1
X_7100_ _7100_/Y _5364_/C _7100_/A2 _7099_/Y VPWR VGND sg13g2_o21ai_1
X_7031_ _8831_/D _8346_/A1 _7008_/Y _7030_/Y VPWR VGND sg13g2_o21ai_1
XFILLER_113_188 VPWR VGND sg13g2_fill_2
XFILLER_113_177 VPWR VGND sg13g2_decap_8
X_9571__2819 _9571_/RESET_B VPWR VGND sg13g2_tiehi
XFILLER_87_529 VPWR VGND sg13g2_decap_8
Xclkbuf_leaf_5_clk_i _9675_/CLK clkload2/A VPWR VGND sg13g2_buf_16
X_8982_ _8982_/Q _9199_/CLK _8982_/D place2425/X VPWR VGND sg13g2_dfrbpq_1
XFILLER_68_776 VPWR VGND sg13g2_fill_2
X_7933_ _8978_/D _5363_/C _7946_/A _7932_/Y VPWR VGND sg13g2_o21ai_1
XFILLER_67_286 VPWR VGND sg13g2_fill_1
XFILLER_27_128 VPWR VGND sg13g2_fill_2
X_7864_ _8939_/D _8939_/Q _7477_/Y _7884_/S VPWR VGND sg13g2_mux2_1
XFILLER_82_289 VPWR VGND sg13g2_fill_1
XFILLER_63_481 VPWR VGND sg13g2_decap_8
XFILLER_35_161 VPWR VGND sg13g2_fill_2
X_9603_ _9603_/Q _9603_/CLK _9603_/D _9603_/RESET_B VPWR VGND sg13g2_dfrbpq_1
X_7795_ _7795_/Y _7795_/A VPWR VGND sg13g2_inv_1
X_6815_ _9563_/D _9596_/Q _9563_/Q _6839_/S VPWR VGND sg13g2_mux2_1
XFILLER_23_334 VPWR VGND sg13g2_fill_2
X_9534_ _9534_/Q _9582_/CLK _9534_/D _9534_/RESET_B VPWR VGND sg13g2_dfrbpq_1
XFILLER_50_164 VPWR VGND sg13g2_decap_8
X_6746_ _9505_/D _9505_/Q _9415_/Q _6756_/S VPWR VGND sg13g2_mux2_1
X_6677_ _6677_/Y _9644_/Q _9649_/Q _9647_/Q _9646_/Q VPWR VGND sg13g2_nor4_1
X_9465_ _9465_/Q _9501_/CLK _9465_/D _9465_/RESET_B VPWR VGND sg13g2_dfrbpq_1
X_8416_ _8416_/Y _8428_/A _9212_/Q _9221_/D VPWR VGND sg13g2_nand3_1
X_9396_ _9396_/Q _9407_/CLK _9396_/D place2507/X VPWR VGND sg13g2_dfrbpq_1
X_5628_ _5658_/A _6915_/A _5628_/B _5629_/C _5629_/B VPWR VGND sg13g2_nand4_1
X_5559_ _5559_/Y _9439_/Q _5570_/B _5580_/B1 _8641_/Q VPWR VGND sg13g2_a22oi_1
X_8347_ _8347_/Y _9174_/Q _8347_/B VPWR VGND sg13g2_nand2_1
XFILLER_105_634 VPWR VGND sg13g2_decap_8
XFILLER_4_7 VPWR VGND sg13g2_decap_8
XFILLER_2_238 VPWR VGND sg13g2_decap_8
X_8278_ _9139_/D _8288_/A1 _8089_/Y _8277_/Y VPWR VGND sg13g2_o21ai_1
XFILLER_120_626 VPWR VGND sg13g2_decap_4
XFILLER_105_689 VPWR VGND sg13g2_decap_8
X_7229_ _7229_/Y _7237_/A1 _9499_/Q _7229_/B1 _7229_/B2 VPWR VGND sg13g2_a22oi_1
XFILLER_120_659 VPWR VGND sg13g2_decap_8
XFILLER_74_746 VPWR VGND sg13g2_fill_2
XFILLER_74_735 VPWR VGND sg13g2_decap_8
XFILLER_46_448 VPWR VGND sg13g2_decap_8
XFILLER_46_459 VPWR VGND sg13g2_fill_2
XFILLER_26_172 VPWR VGND sg13g2_decap_4
XFILLER_27_673 VPWR VGND sg13g2_decap_4
XFILLER_14_334 VPWR VGND sg13g2_fill_1
XFILLER_26_183 VPWR VGND sg13g2_fill_2
XFILLER_41_142 VPWR VGND sg13g2_fill_2
XFILLER_41_94 VPWR VGND sg13g2_fill_1
XFILLER_123_420 VPWR VGND sg13g2_fill_1
XFILLER_6_588 VPWR VGND sg13g2_fill_1
XFILLER_123_442 VPWR VGND sg13g2_decap_8
XFILLER_18_640 VPWR VGND sg13g2_decap_8
XFILLER_37_459 VPWR VGND sg13g2_decap_8
XFILLER_92_598 VPWR VGND sg13g2_fill_1
XFILLER_92_587 VPWR VGND sg13g2_decap_8
X_4930_ _4931_/B _9394_/Q _4934_/B _4929_/Y VPWR VGND sg13g2_a21oi_1
X_4861_ _4861_/Y _4833_/A _4823_/B _4925_/A2 VPWR VGND sg13g2_a21oi_1
X_6600_ _6600_/Y _6600_/A _6660_/B VPWR VGND sg13g2_nand2_1
XFILLER_82_90 VPWR VGND sg13g2_fill_1
X_7580_ _7581_/C _9214_/Q _7695_/A2 _7846_/B1 _7580_/B2 VPWR VGND sg13g2_a22oi_1
X_4792_ _4792_/Y _4928_/C _4791_/Y _6010_/A0 VPWR VGND sg13g2_o21ai_1
XFILLER_32_197 VPWR VGND sg13g2_decap_8
XFILLER_119_715 VPWR VGND sg13g2_fill_1
XFILLER_118_203 VPWR VGND sg13g2_fill_2
X_6531_ _9408_/D _6530_/Y _6534_/B _6535_/S VPWR VGND sg13g2_mux2_1
XFILLER_119_759 VPWR VGND sg13g2_decap_8
XFILLER_119_748 VPWR VGND sg13g2_decap_4
X_6462_ _6462_/Y _8887_/Q _6462_/A2 _6461_/X _6515_/B1 _6460_/Y VPWR VGND sg13g2_a221oi_1
X_9250_ _9250_/Q _9251_/CLK _9250_/D place2480/X VPWR VGND sg13g2_dfrbpq_1
XFILLER_63_0 VPWR VGND sg13g2_decap_8
X_8201_ _8201_/Y _9101_/Q _8221_/B VPWR VGND sg13g2_nand2_1
X_5413_ _5415_/B _8749_/Q _5394_/B _5412_/Y _8748_/Q VPWR VGND sg13g2_a22oi_1
X_9181_ _9181_/Q clkload5/A _9181_/D place2498/X VPWR VGND sg13g2_dfrbpq_1
X_6393_ _6393_/X _9001_/Q _9063_/Q _9125_/Q _9187_/Q _6400_/S0 _6400_/S1 VPWR VGND
+ sg13g2_mux4_1
XFILLER_114_420 VPWR VGND sg13g2_fill_1
X_5344_ _8784_/D _5360_/A _5360_/B _5344_/C _5360_/D VPWR VGND sg13g2_nor4_1
X_8132_ _9066_/D _8164_/A1 _7920_/Y _8131_/Y VPWR VGND sg13g2_o21ai_1
XFILLER_99_131 VPWR VGND sg13g2_decap_8
XFILLER_102_615 VPWR VGND sg13g2_fill_2
X_5275_ _5275_/Y _8426_/C _9493_/Q VPWR VGND sg13g2_nand2_1
X_8063_ _8063_/Y _8063_/A _8101_/B VPWR VGND sg13g2_nand2_1
Xhold2925 _8715_/D _8714_/Q VPWR VGND sg13g2_dlygate4sd3_1
X_7014_ _7014_/Y _7014_/A _8097_/B VPWR VGND sg13g2_nand2_1
Xhold2936 hold2936/X _9702_/Q VPWR VGND sg13g2_dlygate4sd3_1
Xhold2947 _5645_/B1 _8614_/Q VPWR VGND sg13g2_dlygate4sd3_1
XFILLER_101_158 VPWR VGND sg13g2_decap_4
Xhold2969 _6355_/B1 _9379_/Q VPWR VGND sg13g2_dlygate4sd3_1
Xhold2958 _6402_/B1 _9388_/Q VPWR VGND sg13g2_dlygate4sd3_1
XFILLER_83_532 VPWR VGND sg13g2_fill_1
XFILLER_28_426 VPWR VGND sg13g2_fill_2
X_8965_ _8965_/Q clkload8/A _8965_/D place2466/X VPWR VGND sg13g2_dfrbpq_1
XFILLER_43_407 VPWR VGND sg13g2_decap_8
X_8896_ _8896_/Q _9603_/CLK _8896_/D place2431/X VPWR VGND sg13g2_dfrbpq_1
XFILLER_71_738 VPWR VGND sg13g2_decap_8
XFILLER_71_727 VPWR VGND sg13g2_decap_4
X_7916_ _8971_/D _5356_/C _7917_/A _7915_/Y VPWR VGND sg13g2_o21ai_1
XFILLER_24_610 VPWR VGND sg13g2_fill_1
X_7847_ _7847_/Y _7846_/Y _7842_/Y _7459_/A VPWR VGND sg13g2_a21oi_1
XFILLER_70_259 VPWR VGND sg13g2_fill_1
XFILLER_62_49 VPWR VGND sg13g2_fill_2
XFILLER_24_665 VPWR VGND sg13g2_decap_8
X_7778_ _7780_/C _7783_/C _7803_/B _9110_/Q VPWR VGND sg13g2_nor3_1
X_6729_ _9497_/D _9538_/Q _9497_/Q _6729_/S VPWR VGND sg13g2_mux2_1
X_9517_ _9517_/Q _9686_/CLK _9517_/D _9517_/RESET_B VPWR VGND sg13g2_dfrbpq_1
X_9448_ _9448_/Q _9567_/CLK _9448_/D fanout980/X VPWR VGND sg13g2_dfrbpq_1
X_9379_ _9379_/Q _9414_/CLK _9379_/D place2503/X VPWR VGND sg13g2_dfrbpq_1
XFILLER_120_412 VPWR VGND sg13g2_decap_8
XFILLER_86_370 VPWR VGND sg13g2_decap_4
XFILLER_19_426 VPWR VGND sg13g2_decap_8
XFILLER_19_437 VPWR VGND sg13g2_fill_1
XFILLER_19_448 VPWR VGND sg13g2_decap_8
XFILLER_62_705 VPWR VGND sg13g2_fill_2
XFILLER_34_418 VPWR VGND sg13g2_decap_8
XFILLER_46_278 VPWR VGND sg13g2_fill_1
XFILLER_70_782 VPWR VGND sg13g2_decap_8
XFILLER_30_613 VPWR VGND sg13g2_fill_1
Xplace2209 _6948_/B _9633_/Q VPWR VGND sg13g2_buf_1
XFILLER_96_134 VPWR VGND sg13g2_decap_8
XFILLER_96_123 VPWR VGND sg13g2_decap_8
X_5060_ _5117_/D _5123_/A _9262_/Q VPWR VGND sg13g2_and2_1
XFILLER_2_591 VPWR VGND sg13g2_decap_8
XFILLER_77_392 VPWR VGND sg13g2_fill_1
XFILLER_65_565 VPWR VGND sg13g2_decap_8
XFILLER_38_779 VPWR VGND sg13g2_decap_4
X_5962_ _5962_/Y _9488_/Q _5781_/Y _5841_/X _5980_/B2 VPWR VGND sg13g2_a22oi_1
X_8750_ _8750_/Q _9305_/CLK _8750_/D place2407/X VPWR VGND sg13g2_dfrbpq_1
XFILLER_65_576 VPWR VGND sg13g2_fill_1
XFILLER_25_418 VPWR VGND sg13g2_decap_8
XFILLER_92_395 VPWR VGND sg13g2_decap_8
XFILLER_80_557 VPWR VGND sg13g2_decap_8
X_7701_ _7704_/B _7705_/A _9013_/Q _7701_/C VPWR VGND sg13g2_nor3_1
X_4913_ _4913_/Y _4913_/A _4937_/C _4998_/B VPWR VGND sg13g2_nand3_1
XFILLER_46_790 VPWR VGND sg13g2_fill_1
X_5893_ _5893_/X _5890_/Y _5891_/Y _5892_/Y VPWR VGND sg13g2_a21o_1
X_8681_ _8681_/Q _9630_/CLK _8681_/D fanout943/X VPWR VGND sg13g2_dfrbpq_1
XFILLER_21_602 VPWR VGND sg13g2_fill_2
XFILLER_21_613 VPWR VGND sg13g2_fill_1
X_7632_ _7636_/A _7626_/Y _7631_/Y _7028_/A VPWR VGND sg13g2_a21oi_1
X_4844_ _4844_/Y _4959_/B _4844_/B _4998_/B VPWR VGND sg13g2_nand3_1
XFILLER_20_134 VPWR VGND sg13g2_decap_4
XFILLER_21_668 VPWR VGND sg13g2_decap_8
X_4775_ _4791_/C _4793_/B _4923_/A VPWR VGND sg13g2_and2_1
X_7563_ _7565_/B _9161_/Q _7838_/B VPWR VGND sg13g2_nor2_1
X_9302_ _9302_/Q _9305_/CLK _9302_/D place2405/X VPWR VGND sg13g2_dfrbpq_1
X_6514_ _6514_/X _8826_/Q _8828_/Q _8830_/Q _8832_/Q _6514_/S0 _6514_/S1 VPWR VGND
+ sg13g2_mux4_1
XFILLER_20_167 VPWR VGND sg13g2_decap_8
Xclkbuf_leaf_23_clk_i _9406_/CLK clkload1/A VPWR VGND sg13g2_buf_16
X_9233_ _9233_/Q _9242_/CLK _9233_/D place2494/X VPWR VGND sg13g2_dfrbpq_1
X_7494_ _7494_/Y _7494_/A _7494_/B _7494_/C _7494_/D VPWR VGND sg13g2_nor4_1
X_6445_ _6445_/Y _6443_/Y _6444_/Y _6455_/A VPWR VGND sg13g2_a21oi_1
X_9164_ _9164_/Q _9611_/CLK _9164_/D place2411/X VPWR VGND sg13g2_dfrbpq_1
X_6376_ _9382_/D _6371_/Y _6375_/Y _6373_/Y VPWR VGND sg13g2_a21oi_1
XFILLER_87_101 VPWR VGND sg13g2_fill_1
X_5327_ _5334_/C _5339_/D _5339_/C VPWR VGND sg13g2_nor2_1
X_9095_ _9095_/Q clkload8/A _9095_/D place2466/X VPWR VGND sg13g2_dfrbpq_1
X_8115_ _8115_/Y _8115_/A _8163_/B VPWR VGND sg13g2_nand2_1
XFILLER_88_668 VPWR VGND sg13g2_decap_8
XFILLER_87_145 VPWR VGND sg13g2_decap_8
X_8046_ _8046_/Y _8046_/A _8052_/B VPWR VGND sg13g2_nand2_1
X_5258_ _5363_/C _8517_/C _9490_/Q VPWR VGND sg13g2_nand2_1
XFILLER_75_307 VPWR VGND sg13g2_fill_1
XFILLER_57_38 VPWR VGND sg13g2_fill_1
X_5189_ _5191_/C _5192_/D _5192_/C VPWR VGND sg13g2_nand2_1
XFILLER_68_381 VPWR VGND sg13g2_fill_2
XFILLER_56_532 VPWR VGND sg13g2_decap_8
XFILLER_28_256 VPWR VGND sg13g2_fill_1
XFILLER_29_779 VPWR VGND sg13g2_fill_2
X_8948_ _8948_/Q _9615_/CLK _8948_/D place2417/X VPWR VGND sg13g2_dfrbpq_1
XFILLER_113_88 VPWR VGND sg13g2_decap_8
XFILLER_83_373 VPWR VGND sg13g2_fill_1
XFILLER_73_37 VPWR VGND sg13g2_decap_8
XFILLER_16_418 VPWR VGND sg13g2_decap_4
XFILLER_83_395 VPWR VGND sg13g2_decap_8
XFILLER_43_237 VPWR VGND sg13g2_fill_2
XFILLER_71_579 VPWR VGND sg13g2_decap_8
X_8879_ _8879_/Q _9407_/CLK _8879_/D place2454/X VPWR VGND sg13g2_dfrbpq_1
XFILLER_52_760 VPWR VGND sg13g2_fill_1
XFILLER_11_101 VPWR VGND sg13g2_decap_4
Xinput2610 _6071_/B slave_addr_i[0] VPWR VGND sg13g2_buf_1
XFILLER_11_134 VPWR VGND sg13g2_decap_8
XFILLER_7_105 VPWR VGND sg13g2_decap_4
Xinput2621 _6539_/A1 slave_aid_i[3] VPWR VGND sg13g2_buf_1
Xinput2632 _7194_/B slave_wdata_i[18] VPWR VGND sg13g2_buf_1
Xinput2643 _7228_/B slave_wdata_i[28] VPWR VGND sg13g2_buf_1
XFILLER_7_138 VPWR VGND sg13g2_fill_1
Xinput2654 _7162_/A slave_wdata_i[9] VPWR VGND sg13g2_buf_1
XFILLER_3_300 VPWR VGND sg13g2_decap_4
XFILLER_3_344 VPWR VGND sg13g2_fill_1
XFILLER_79_668 VPWR VGND sg13g2_decap_8
XFILLER_67_808 VPWR VGND sg13g2_fill_1
XFILLER_78_156 VPWR VGND sg13g2_decap_8
XFILLER_87_690 VPWR VGND sg13g2_decap_8
XFILLER_14_9 VPWR VGND sg13g2_fill_1
XFILLER_35_727 VPWR VGND sg13g2_decap_4
XFILLER_15_451 VPWR VGND sg13g2_fill_1
XFILLER_43_782 VPWR VGND sg13g2_fill_1
XFILLER_8_21 VPWR VGND sg13g2_decap_8
XFILLER_30_443 VPWR VGND sg13g2_decap_8
XFILLER_42_292 VPWR VGND sg13g2_fill_2
X_4560_ _4560_/Y _7245_/C _4560_/B _7244_/D _4560_/D VPWR VGND sg13g2_nor4_1
Xplace2028 _6729_/S _6714_/S VPWR VGND sg13g2_buf_1
Xplace2006 _5593_/B1 _6546_/D VPWR VGND sg13g2_buf_1
Xplace2017 _5469_/A1 _4387_/Y VPWR VGND sg13g2_buf_1
X_9534__2846 _9534_/RESET_B VPWR VGND sg13g2_tiehi
X_4491_ _4491_/Y hold3021/X _4491_/B VPWR VGND sg13g2_nand2b_1
Xplace2039 _8226_/A1 _5836_/D VPWR VGND sg13g2_buf_1
X_6230_ _6230_/X _8979_/Q _9041_/Q _9103_/Q _9165_/Q _6440_/S0 _6440_/S1 VPWR VGND
+ sg13g2_mux4_1
XFILLER_6_182 VPWR VGND sg13g2_decap_4
XFILLER_112_710 VPWR VGND sg13g2_fill_1
XFILLER_97_410 VPWR VGND sg13g2_fill_2
X_6161_ _6161_/Y _6161_/A _6176_/A _6161_/C VPWR VGND sg13g2_nand3_1
XFILLER_97_432 VPWR VGND sg13g2_fill_1
X_5112_ _5112_/Y _5132_/A _5132_/B _5160_/B _5124_/B VPWR VGND sg13g2_nor4_1
X_6092_ _6094_/C _9235_/Q _6092_/B VPWR VGND sg13g2_nor2_1
X_5043_ _5146_/C _5132_/A _8517_/B VPWR VGND sg13g2_nand2_1
XFILLER_84_115 VPWR VGND sg13g2_fill_2
XFILLER_84_104 VPWR VGND sg13g2_fill_1
X_8802_ _8802_/Q _9219_/CLK _8802_/D place2407/X VPWR VGND sg13g2_dfrbpq_1
XFILLER_65_384 VPWR VGND sg13g2_decap_4
XFILLER_65_362 VPWR VGND sg13g2_fill_2
XFILLER_65_351 VPWR VGND sg13g2_fill_1
XFILLER_53_502 VPWR VGND sg13g2_fill_1
X_6994_ _6994_/Y _7245_/A _9467_/Q _7244_/C _6994_/D VPWR VGND sg13g2_nor4_1
X_5945_ _5945_/Y _5945_/A _5945_/B VPWR VGND sg13g2_nand2_1
X_8733_ _8733_/Q _9686_/CLK _8733_/D fanout962/X VPWR VGND sg13g2_dfrbpq_1
XFILLER_53_568 VPWR VGND sg13g2_decap_4
X_5876_ _5876_/Y _5939_/A _5873_/X _5925_/C VPWR VGND sg13g2_o21ai_1
X_8664_ _8664_/Q _8664_/CLK _8664_/D input2574/X VPWR VGND sg13g2_dfrbpq_1
XFILLER_33_270 VPWR VGND sg13g2_fill_1
X_7615_ _7616_/B _7615_/A _7615_/B _7615_/C _7615_/D VPWR VGND sg13g2_and4_1
XFILLER_21_432 VPWR VGND sg13g2_decap_4
X_4827_ _4945_/C _4827_/A _4827_/B VPWR VGND sg13g2_nor2_1
X_8595_ _8595_/Q _8678_/CLK _8595_/D fanout947/X VPWR VGND sg13g2_dfrbpq_1
X_7546_ _7548_/C _7651_/A _7644_/B _9098_/Q VPWR VGND sg13g2_nor3_1
X_4758_ _4928_/C _4776_/B _9340_/Q VPWR VGND sg13g2_nor2b_1
X_4689_ _9657_/D _6954_/S _4687_/B _4688_/Y VPWR VGND sg13g2_o21ai_1
X_7477_ _7477_/Y _7473_/Y _7476_/X _5377_/X VPWR VGND sg13g2_a21oi_1
XFILLER_108_44 VPWR VGND sg13g2_fill_1
XFILLER_104_7 VPWR VGND sg13g2_decap_8
X_9216_ _9216_/Q _9304_/CLK _9216_/D place2409/X VPWR VGND sg13g2_dfrbpq_1
X_6428_ _9393_/D _6505_/A2 _6426_/Y _6427_/Y VPWR VGND sg13g2_a21oi_1
XFILLER_122_507 VPWR VGND sg13g2_fill_2
XFILLER_108_77 VPWR VGND sg13g2_decap_8
Xplace1850 _6902_/S _6904_/S VPWR VGND sg13g2_buf_1
Xplace1861 _8585_/A2 _5786_/Y VPWR VGND sg13g2_buf_1
X_9147_ _9147_/Q _9188_/CLK _9147_/D place2484/X VPWR VGND sg13g2_dfrbpq_1
Xplace1872 _8492_/A _8448_/A VPWR VGND sg13g2_buf_1
Xhold3231 _8339_/A _9170_/Q VPWR VGND sg13g2_dlygate4sd3_1
Xplace1894 _6783_/S _6785_/S VPWR VGND sg13g2_buf_1
Xplace1883 _7123_/C _7129_/C VPWR VGND sg13g2_buf_1
Xhold3220 _5432_/A1 _8671_/Q VPWR VGND sg13g2_dlygate4sd3_1
X_6359_ _6359_/Y _8868_/Q _6375_/A2 _6129_/A _6358_/X VPWR VGND sg13g2_a22oi_1
Xhold3242 _5663_/A1 _8609_/Q VPWR VGND sg13g2_dlygate4sd3_1
X_9078_ _9078_/Q _9504_/CLK _9078_/D place2432/X VPWR VGND sg13g2_dfrbpq_1
X_8029_ _8029_/Y _8039_/A _8039_/B _8039_/C _8029_/D VPWR VGND sg13g2_nand4_1
XFILLER_84_25 VPWR VGND sg13g2_fill_2
XFILLER_84_14 VPWR VGND sg13g2_decap_8
XFILLER_56_340 VPWR VGND sg13g2_decap_8
XFILLER_17_705 VPWR VGND sg13g2_decap_8
XFILLER_17_30 VPWR VGND sg13g2_fill_1
X_9584__2806 _9584_/RESET_B VPWR VGND sg13g2_tiehi
XFILLER_83_181 VPWR VGND sg13g2_fill_1
XFILLER_16_248 VPWR VGND sg13g2_fill_1
X_9620__2770 _9620_/RESET_B VPWR VGND sg13g2_tiehi
XFILLER_71_354 VPWR VGND sg13g2_fill_2
XFILLER_32_708 VPWR VGND sg13g2_decap_8
XFILLER_4_642 VPWR VGND sg13g2_decap_8
XFILLER_113_518 VPWR VGND sg13g2_decap_4
XFILLER_3_196 VPWR VGND sg13g2_decap_8
XFILLER_67_605 VPWR VGND sg13g2_decap_8
XFILLER_94_413 VPWR VGND sg13g2_decap_8
XFILLER_66_115 VPWR VGND sg13g2_decap_4
XFILLER_94_457 VPWR VGND sg13g2_fill_1
XFILLER_75_660 VPWR VGND sg13g2_fill_2
XFILLER_35_535 VPWR VGND sg13g2_decap_8
XFILLER_62_365 VPWR VGND sg13g2_fill_2
X_5730_ _5730_/Y _5739_/A _9318_/Q VPWR VGND sg13g2_nand2_1
XFILLER_43_590 VPWR VGND sg13g2_decap_8
X_7400_ _7402_/B _7400_/A1 _7737_/B1 _7269_/X _4521_/Y VPWR VGND sg13g2_a22oi_1
X_5661_ _5662_/B _4457_/X _5629_/A _5657_/A VPWR VGND sg13g2_a21oi_1
X_5592_ _5592_/Y _8653_/Q _5592_/A2 _5601_/B1 _8652_/Q VPWR VGND sg13g2_a22oi_1
X_4612_ _4715_/A _9678_/Q _4614_/D VPWR VGND sg13g2_nor2_1
X_8380_ _9190_/D _5358_/C _8383_/A _8379_/Y VPWR VGND sg13g2_o21ai_1
X_4543_ _4562_/A _8515_/A _8515_/B _4542_/Y VPWR VGND sg13g2_a21o_1
X_7331_ _7331_/Y _9056_/Q _7351_/B _7333_/A VPWR VGND sg13g2_nand3b_1
XFILLER_116_356 VPWR VGND sg13g2_decap_8
XFILLER_116_345 VPWR VGND sg13g2_decap_8
X_7262_ _7262_/X _9221_/Q _7520_/B VPWR VGND sg13g2_and2_1
X_4474_ _4475_/B _4474_/A _4365_/B VPWR VGND sg13g2_nor2b_1
X_6213_ _6213_/Y _6504_/A1 _6463_/A2 _6213_/B1 VPWR VGND sg13g2_a21oi_1
X_9001_ _9001_/Q clkload4/A _9001_/D place2481/X VPWR VGND sg13g2_dfrbpq_1
X_7193_ _8881_/D _7192_/Y _8881_/Q _7213_/S VPWR VGND sg13g2_mux2_1
Xfanout938 _5925_/C _5954_/C VPWR VGND sg13g2_buf_1
XFILLER_112_551 VPWR VGND sg13g2_decap_8
X_6144_ _6145_/C _6451_/D _6333_/C _6144_/C _6144_/D VPWR VGND sg13g2_nor4_1
Xfanout949 fanout949/X fanout950/X VPWR VGND sg13g2_buf_1
XFILLER_97_295 VPWR VGND sg13g2_decap_8
XFILLER_85_413 VPWR VGND sg13g2_decap_8
X_6075_ _6075_/Y _6379_/A1 _6346_/B _6075_/B1 VPWR VGND sg13g2_a21oi_1
XFILLER_38_29 VPWR VGND sg13g2_decap_4
X_5026_ _5026_/Y _5177_/A _9863_/A _5065_/C _9862_/A _5025_/Y VPWR VGND sg13g2_a221oi_1
XFILLER_57_159 VPWR VGND sg13g2_fill_2
XFILLER_73_619 VPWR VGND sg13g2_decap_4
XFILLER_66_660 VPWR VGND sg13g2_fill_2
XFILLER_81_630 VPWR VGND sg13g2_decap_8
XFILLER_54_39 VPWR VGND sg13g2_decap_8
XFILLER_53_332 VPWR VGND sg13g2_fill_2
XFILLER_26_524 VPWR VGND sg13g2_decap_4
X_6977_ _6977_/Y _7237_/B1 _6032_/Y _7820_/C VPWR VGND sg13g2_a21oi_1
XFILLER_41_505 VPWR VGND sg13g2_decap_8
X_5928_ _5928_/Y _9318_/Q _5981_/B VPWR VGND sg13g2_nand2_1
X_8716_ _8716_/Q _9662_/CLK _8716_/D place2445/X VPWR VGND sg13g2_dfrbpq_1
XFILLER_81_696 VPWR VGND sg13g2_fill_1
XFILLER_53_376 VPWR VGND sg13g2_fill_2
XFILLER_13_218 VPWR VGND sg13g2_decap_8
XFILLER_13_229 VPWR VGND sg13g2_fill_1
XFILLER_110_67 VPWR VGND sg13g2_fill_1
XFILLER_80_195 VPWR VGND sg13g2_fill_2
X_9696_ _9696_/Q _9708_/CLK _9696_/D fanout953/X VPWR VGND sg13g2_dfrbpq_1
X_8647_ _8647_/Q _9449_/CLK _8647_/D fanout971/X VPWR VGND sg13g2_dfrbpq_1
X_5859_ _5859_/Y _5891_/A1 _5906_/A2 _5859_/B1 _5891_/B2 VPWR VGND sg13g2_a22oi_1
X_8578_ _9281_/D _5888_/Y _8563_/X _8577_/Y VPWR VGND sg13g2_o21ai_1
XFILLER_119_21 VPWR VGND sg13g2_decap_8
X_7529_ _7530_/D _9035_/Q _7816_/B _7528_/Y VPWR VGND sg13g2_o21ai_1
Xplace2392 place2392/X place2400/X VPWR VGND sg13g2_buf_1
Xplace2370 _8407_/C _5203_/A VPWR VGND sg13g2_buf_1
Xplace2381 _5203_/A _6959_/B VPWR VGND sg13g2_buf_1
XFILLER_89_774 VPWR VGND sg13g2_fill_2
XFILLER_88_251 VPWR VGND sg13g2_decap_8
Xhold3050 _6427_/B1 _9393_/Q VPWR VGND sg13g2_dlygate4sd3_1
XFILLER_49_605 VPWR VGND sg13g2_fill_2
XFILLER_95_57 VPWR VGND sg13g2_decap_8
Xhold3072 _4594_/A _4593_/Y VPWR VGND sg13g2_dlygate4sd3_1
Xhold3083 _5651_/B2 _8617_/Q VPWR VGND sg13g2_dlygate4sd3_1
Xhold3061 _5603_/A _9415_/Q VPWR VGND sg13g2_dlygate4sd3_1
XFILLER_48_115 VPWR VGND sg13g2_decap_4
Xhold3094 _5675_/B2 _8591_/Q VPWR VGND sg13g2_dlygate4sd3_1
XFILLER_28_73 VPWR VGND sg13g2_decap_8
XFILLER_56_192 VPWR VGND sg13g2_fill_2
XFILLER_72_663 VPWR VGND sg13g2_decap_4
XFILLER_71_151 VPWR VGND sg13g2_decap_8
XFILLER_17_557 VPWR VGND sg13g2_decap_8
XFILLER_32_505 VPWR VGND sg13g2_decap_8
XFILLER_44_387 VPWR VGND sg13g2_fill_2
XFILLER_12_251 VPWR VGND sg13g2_decap_4
XFILLER_40_560 VPWR VGND sg13g2_fill_2
XFILLER_12_273 VPWR VGND sg13g2_decap_4
XFILLER_60_82 VPWR VGND sg13g2_decap_8
XFILLER_113_304 VPWR VGND sg13g2_decap_8
XFILLER_113_348 VPWR VGND sg13g2_fill_1
XFILLER_5_99 VPWR VGND sg13g2_decap_4
XFILLER_67_402 VPWR VGND sg13g2_fill_2
XFILLER_95_777 VPWR VGND sg13g2_fill_2
XFILLER_95_766 VPWR VGND sg13g2_fill_1
X_9484__2896 _9484_/RESET_B VPWR VGND sg13g2_tiehi
XFILLER_36_800 VPWR VGND sg13g2_fill_1
X_7880_ _8953_/D _8953_/Q _7754_/Y _7881_/S VPWR VGND sg13g2_mux2_1
X_6900_ _9616_/D _6899_/X _9616_/Q _6900_/S VPWR VGND sg13g2_mux2_1
XFILLER_82_449 VPWR VGND sg13g2_decap_8
XFILLER_63_630 VPWR VGND sg13g2_decap_8
X_6831_ _9579_/D _9612_/Q _9579_/Q _6834_/S VPWR VGND sg13g2_mux2_1
XFILLER_90_460 VPWR VGND sg13g2_decap_8
XFILLER_62_151 VPWR VGND sg13g2_decap_8
XFILLER_90_493 VPWR VGND sg13g2_fill_1
X_9550_ _9550_/Q _9672_/CLK _9550_/D place2442/X VPWR VGND sg13g2_dfrbpq_1
XFILLER_23_516 VPWR VGND sg13g2_fill_2
X_6762_ _9521_/D _9521_/Q _9431_/Q _6781_/S VPWR VGND sg13g2_mux2_1
X_8501_ _8502_/C _8501_/A _8503_/B VPWR VGND sg13g2_and2_1
X_6693_ _9463_/D _9463_/Q _8513_/B _6692_/Y VPWR VGND sg13g2_a21oi_1
X_5713_ _5713_/X _5716_/A _9310_/Q _5716_/C VPWR VGND sg13g2_and3_1
X_9481_ _9481_/Q _9504_/CLK _9481_/D _9481_/RESET_B VPWR VGND sg13g2_dfrbpq_1
X_8432_ _8432_/Y _8432_/A _9220_/Q _8432_/C VPWR VGND sg13g2_nand3_1
XFILLER_31_582 VPWR VGND sg13g2_decap_8
XFILLER_31_593 VPWR VGND sg13g2_fill_1
X_5644_ _5646_/A _8615_/Q _5660_/B VPWR VGND sg13g2_nor2_1
XFILLER_117_610 VPWR VGND sg13g2_decap_4
X_8363_ _8363_/Y _8367_/A _9182_/Q _8365_/C VPWR VGND sg13g2_nand3_1
X_5575_ _8646_/D _5574_/Y _5573_/Y _5581_/B1 VPWR VGND sg13g2_a21oi_1
X_7314_ _7318_/B _9024_/Q _7385_/B VPWR VGND sg13g2_nor2_1
XFILLER_116_164 VPWR VGND sg13g2_decap_8
XFILLER_104_304 VPWR VGND sg13g2_decap_4
X_4526_ _4526_/Y _8747_/Q _8748_/Q VPWR VGND sg13g2_nor2_1
X_8294_ _9147_/D _8314_/A1 _7892_/Y _8293_/Y VPWR VGND sg13g2_o21ai_1
X_7245_ _7245_/Y _7245_/A _7245_/B _7245_/C _7245_/D VPWR VGND sg13g2_nor4_1
X_4457_ _4457_/X _9623_/Q _9627_/Q _5629_/B VPWR VGND sg13g2_and3_1
XFILLER_104_359 VPWR VGND sg13g2_decap_4
X_7176_ _7176_/Y _7818_/B _9484_/Q _7237_/B1 _7176_/B2 VPWR VGND sg13g2_a22oi_1
X_6127_ _6131_/A _6145_/B _6126_/Y _6039_/X VPWR VGND sg13g2_o21ai_1
X_4388_ _4388_/X _4591_/B _4389_/B VPWR VGND sg13g2_and2_1
X_6058_ _6073_/B _6090_/A _6038_/B _6039_/X VPWR VGND sg13g2_o21ai_1
XFILLER_39_660 VPWR VGND sg13g2_decap_8
X_5009_ _5009_/Y _4903_/C _4833_/A _5012_/A VPWR VGND sg13g2_o21ai_1
XFILLER_26_332 VPWR VGND sg13g2_fill_2
XFILLER_81_493 VPWR VGND sg13g2_decap_4
XFILLER_53_184 VPWR VGND sg13g2_fill_2
XFILLER_81_48 VPWR VGND sg13g2_fill_1
XFILLER_81_37 VPWR VGND sg13g2_decap_4
XFILLER_41_335 VPWR VGND sg13g2_fill_2
X_9679_ _9679_/Q _9689_/CLK _9679_/D fanout962/X VPWR VGND sg13g2_dfrbpq_1
XFILLER_10_777 VPWR VGND sg13g2_fill_1
XFILLER_10_766 VPWR VGND sg13g2_decap_8
XFILLER_108_621 VPWR VGND sg13g2_fill_2
XFILLER_107_120 VPWR VGND sg13g2_decap_8
XFILLER_123_624 VPWR VGND sg13g2_decap_8
XFILLER_107_175 VPWR VGND sg13g2_decap_8
XFILLER_122_134 VPWR VGND sg13g2_fill_2
XFILLER_89_593 VPWR VGND sg13g2_fill_2
XFILLER_77_733 VPWR VGND sg13g2_decap_8
XFILLER_77_744 VPWR VGND sg13g2_fill_2
XFILLER_92_714 VPWR VGND sg13g2_fill_1
XFILLER_92_703 VPWR VGND sg13g2_fill_2
XFILLER_92_736 VPWR VGND sg13g2_fill_2
XFILLER_45_674 VPWR VGND sg13g2_decap_8
X_9469__2911 _9469_/RESET_B VPWR VGND sg13g2_tiehi
XFILLER_20_519 VPWR VGND sg13g2_fill_1
XFILLER_71_92 VPWR VGND sg13g2_fill_1
XFILLER_9_531 VPWR VGND sg13g2_decap_8
X_5360_ _8800_/D _5360_/A _5360_/B _5360_/C _5360_/D VPWR VGND sg13g2_nor4_1
X_4311_ _5086_/B _9259_/Q VPWR VGND sg13g2_inv_1
X_5291_ _5291_/Y _9881_/A _5291_/B _5291_/C _5291_/D VPWR VGND sg13g2_nand4_1
XFILLER_5_770 VPWR VGND sg13g2_decap_8
XFILLER_114_657 VPWR VGND sg13g2_fill_1
XFILLER_113_145 VPWR VGND sg13g2_fill_1
XFILLER_113_134 VPWR VGND sg13g2_decap_8
XFILLER_87_519 VPWR VGND sg13g2_fill_2
XFILLER_87_508 VPWR VGND sg13g2_fill_2
X_7030_ _7030_/Y _7030_/A _8343_/B VPWR VGND sg13g2_nand2_1
XFILLER_101_318 VPWR VGND sg13g2_fill_2
XFILLER_101_307 VPWR VGND sg13g2_decap_8
XFILLER_68_766 VPWR VGND sg13g2_decap_4
XFILLER_67_210 VPWR VGND sg13g2_decap_8
XFILLER_95_585 VPWR VGND sg13g2_decap_4
X_8981_ _8981_/Q _9198_/CLK _8981_/D place2437/X VPWR VGND sg13g2_dfrbpq_1
X_7932_ _7932_/Y _7946_/A _8978_/Q _8389_/C VPWR VGND sg13g2_nand3_1
XFILLER_82_268 VPWR VGND sg13g2_decap_8
XFILLER_35_140 VPWR VGND sg13g2_decap_8
XFILLER_91_780 VPWR VGND sg13g2_decap_4
X_7863_ _8938_/D _8938_/Q _7459_/Y _7884_/S VPWR VGND sg13g2_mux2_1
XFILLER_70_419 VPWR VGND sg13g2_fill_1
XFILLER_51_611 VPWR VGND sg13g2_fill_1
X_9602_ _9602_/Q _9621_/CLK _9602_/D _9602_/RESET_B VPWR VGND sg13g2_dfrbpq_1
X_7794_ _7795_/A _9886_/A _7694_/B _7794_/B1 _8892_/Q VPWR VGND sg13g2_a22oi_1
X_6814_ _9562_/D _9595_/Q _9562_/Q _6839_/S VPWR VGND sg13g2_mux2_1
XFILLER_51_666 VPWR VGND sg13g2_fill_2
XFILLER_51_655 VPWR VGND sg13g2_decap_8
X_9533_ _9533_/Q _9582_/CLK _9533_/D _9533_/RESET_B VPWR VGND sg13g2_dfrbpq_1
X_6745_ _6785_/S _6951_/B _6951_/C _6745_/C _6745_/D VPWR VGND sg13g2_nor4_1
XFILLER_50_143 VPWR VGND sg13g2_decap_8
XFILLER_23_368 VPWR VGND sg13g2_fill_2
XFILLER_23_379 VPWR VGND sg13g2_fill_2
X_9464_ _9464_/Q _9501_/CLK _9464_/D _9464_/RESET_B VPWR VGND sg13g2_dfrbpq_1
X_6676_ _9455_/D _9455_/Q _4640_/C _6678_/B VPWR VGND sg13g2_mux2_1
X_8415_ _9211_/D _5344_/C _8428_/A _8414_/Y VPWR VGND sg13g2_o21ai_1
XFILLER_31_390 VPWR VGND sg13g2_fill_1
X_9395_ _9395_/Q _9406_/CLK _9395_/D place2390/X VPWR VGND sg13g2_dfrbpq_1
X_5627_ _5627_/X _6915_/A _5628_/B _5629_/C _5629_/B VPWR VGND sg13g2_and4_1
X_5558_ _5558_/Y _5585_/A _5585_/B _8642_/Q _5585_/D VPWR VGND sg13g2_nand4_1
X_8346_ _9173_/D _8346_/A1 _7951_/Y _8345_/Y VPWR VGND sg13g2_o21ai_1
X_4509_ _4532_/B _8743_/D _6982_/A _7004_/A VPWR VGND sg13g2_nor3_1
X_8277_ _8277_/Y _9139_/Q _8287_/B VPWR VGND sg13g2_nand2_1
XFILLER_3_729 VPWR VGND sg13g2_fill_1
XFILLER_116_11 VPWR VGND sg13g2_fill_2
XFILLER_104_123 VPWR VGND sg13g2_fill_1
XFILLER_78_519 VPWR VGND sg13g2_decap_4
XFILLER_78_508 VPWR VGND sg13g2_decap_4
X_5489_ _5492_/C _9555_/Q _8726_/Q VPWR VGND sg13g2_nor2_1
X_7228_ _7228_/Y _7236_/A _7228_/B _8496_/B _7236_/D VPWR VGND sg13g2_nand4_1
X_7159_ _7159_/Y _5352_/C _6978_/Y _7158_/Y VPWR VGND sg13g2_o21ai_1
XFILLER_100_340 VPWR VGND sg13g2_fill_2
XFILLER_86_552 VPWR VGND sg13g2_decap_8
XFILLER_74_714 VPWR VGND sg13g2_decap_8
XFILLER_46_405 VPWR VGND sg13g2_decap_4
XFILLER_100_384 VPWR VGND sg13g2_decap_8
XFILLER_18_118 VPWR VGND sg13g2_decap_4
XFILLER_92_14 VPWR VGND sg13g2_fill_1
XFILLER_73_257 VPWR VGND sg13g2_fill_2
XFILLER_54_482 VPWR VGND sg13g2_fill_2
XFILLER_41_110 VPWR VGND sg13g2_decap_8
XFILLER_41_121 VPWR VGND sg13g2_fill_2
XFILLER_6_512 VPWR VGND sg13g2_fill_2
XFILLER_108_495 VPWR VGND sg13g2_decap_4
XFILLER_123_454 VPWR VGND sg13g2_decap_8
Xclkbuf_leaf_14_jtag_tck_i_regs _8678_/CLK clkbuf_leaf_1_jtag_tck_i_regs/A VPWR VGND
+ sg13g2_buf_16
XFILLER_96_305 VPWR VGND sg13g2_fill_2
XFILLER_69_519 VPWR VGND sg13g2_fill_2
XFILLER_1_261 VPWR VGND sg13g2_fill_2
XFILLER_2_762 VPWR VGND sg13g2_decap_4
XFILLER_2_784 VPWR VGND sg13g2_fill_1
XFILLER_110_115 VPWR VGND sg13g2_fill_1
XFILLER_96_349 VPWR VGND sg13g2_fill_2
XFILLER_49_265 VPWR VGND sg13g2_fill_1
XFILLER_65_736 VPWR VGND sg13g2_fill_2
XFILLER_65_725 VPWR VGND sg13g2_decap_4
XFILLER_18_652 VPWR VGND sg13g2_fill_1
XFILLER_52_419 VPWR VGND sg13g2_decap_4
XFILLER_45_460 VPWR VGND sg13g2_decap_8
XFILLER_45_471 VPWR VGND sg13g2_fill_1
X_4860_ _4860_/Y _4816_/A _4791_/C _4899_/C VPWR VGND sg13g2_a21oi_1
XFILLER_32_110 VPWR VGND sg13g2_fill_1
XFILLER_33_666 VPWR VGND sg13g2_fill_1
X_6530_ _6530_/Y _5038_/Y _6524_/Y _6534_/D VPWR VGND sg13g2_a21oi_1
X_4791_ _4791_/Y _4842_/A _4791_/B _4791_/C VPWR VGND sg13g2_nor3_1
XFILLER_32_176 VPWR VGND sg13g2_decap_8
XFILLER_119_727 VPWR VGND sg13g2_fill_2
X_6461_ _6461_/X _9013_/Q _9075_/Q _9137_/Q _9199_/Q _6514_/S0 _6514_/S1 VPWR VGND
+ sg13g2_mux4_1
X_8200_ _9100_/D _8226_/A1 _7928_/Y _8199_/Y VPWR VGND sg13g2_o21ai_1
X_5412_ _5412_/Y _9481_/Q _7010_/A _5412_/C VPWR VGND sg13g2_nand3_1
X_6392_ _9386_/D _6391_/Y _9386_/Q _6392_/S VPWR VGND sg13g2_mux2_1
X_9180_ _9180_/Q clkload5/A _9180_/D place2497/X VPWR VGND sg13g2_dfrbpq_1
XFILLER_56_0 VPWR VGND sg13g2_decap_4
X_8131_ _8131_/Y _8131_/A _8161_/B VPWR VGND sg13g2_nand2_1
X_5343_ _5343_/Y _9466_/Q _5343_/B _9465_/Q VPWR VGND sg13g2_nand3b_1
XFILLER_88_806 VPWR VGND sg13g2_fill_2
XFILLER_102_627 VPWR VGND sg13g2_decap_8
XFILLER_99_165 VPWR VGND sg13g2_decap_8
X_5274_ _8773_/D _5274_/A1 _5365_/C _5273_/Y _5274_/B2 VPWR VGND sg13g2_a22oi_1
X_8062_ _9036_/D _6994_/D _8061_/Y _8060_/Y VPWR VGND sg13g2_o21ai_1
XFILLER_102_638 VPWR VGND sg13g2_fill_1
XFILLER_101_137 VPWR VGND sg13g2_decap_8
Xhold2926 _8728_/D _8727_/Q VPWR VGND sg13g2_dlygate4sd3_1
X_7013_ _8094_/B _7730_/C _7004_/Y _7029_/A VPWR VGND sg13g2_a21oi_1
Xhold2937 _4466_/A2 _9683_/Q VPWR VGND sg13g2_dlygate4sd3_1
Xhold2948 _8614_/D _5646_/Y VPWR VGND sg13g2_dlygate4sd3_1
XFILLER_83_500 VPWR VGND sg13g2_decap_4
Xhold2959 _5657_/A _8607_/Q VPWR VGND sg13g2_dlygate4sd3_1
XFILLER_95_393 VPWR VGND sg13g2_fill_1
XFILLER_83_511 VPWR VGND sg13g2_decap_8
XFILLER_56_747 VPWR VGND sg13g2_fill_2
XFILLER_56_725 VPWR VGND sg13g2_fill_2
XFILLER_83_555 VPWR VGND sg13g2_fill_2
XFILLER_71_706 VPWR VGND sg13g2_decap_8
X_8964_ _8964_/Q clkload5/A _8964_/D place2498/X VPWR VGND sg13g2_dfrbpq_1
X_8895_ _8895_/Q _9611_/CLK _8895_/D place2412/X VPWR VGND sg13g2_dfrbpq_1
XFILLER_83_599 VPWR VGND sg13g2_fill_2
XFILLER_70_227 VPWR VGND sg13g2_fill_2
X_7915_ _7915_/Y _7917_/A _8971_/Q _8375_/C VPWR VGND sg13g2_nand3_1
X_7846_ _7846_/Y _8863_/Q _7846_/A2 _7846_/B1 _7846_/B2 _7845_/Y VPWR VGND sg13g2_a221oi_1
XFILLER_70_249 VPWR VGND sg13g2_fill_1
XFILLER_63_290 VPWR VGND sg13g2_decap_8
XFILLER_24_644 VPWR VGND sg13g2_decap_8
XFILLER_23_132 VPWR VGND sg13g2_fill_2
XFILLER_23_154 VPWR VGND sg13g2_decap_8
X_7777_ _7780_/B _9172_/Q _7782_/B VPWR VGND sg13g2_nor2_1
XFILLER_24_699 VPWR VGND sg13g2_decap_4
X_4989_ _4989_/Y _5012_/A _5012_/B _5012_/D _4989_/D VPWR VGND sg13g2_nand4_1
X_6728_ _9496_/D _9537_/Q _9496_/Q _6729_/S VPWR VGND sg13g2_mux2_1
X_9516_ _9516_/Q _9686_/CLK _9516_/D _9516_/RESET_B VPWR VGND sg13g2_dfrbpq_1
X_9447_ _9447_/Q _9567_/CLK _9447_/D fanout983/X VPWR VGND sg13g2_dfrbpq_1
X_6659_ _9449_/D _6663_/A1 _6658_/Y _6657_/Y VPWR VGND sg13g2_o21ai_1
XFILLER_109_259 VPWR VGND sg13g2_decap_8
X_9378_ _9378_/Q _9414_/CLK _9378_/D place2501/X VPWR VGND sg13g2_dfrbpq_1
X_8329_ _8329_/Y _8329_/A _8345_/B VPWR VGND sg13g2_nand2_1
XFILLER_11_87 VPWR VGND sg13g2_fill_1
XFILLER_78_305 VPWR VGND sg13g2_decap_4
XFILLER_87_69 VPWR VGND sg13g2_fill_1
XFILLER_93_319 VPWR VGND sg13g2_decap_8
XFILLER_93_308 VPWR VGND sg13g2_decap_4
XFILLER_74_500 VPWR VGND sg13g2_decap_8
XFILLER_47_714 VPWR VGND sg13g2_fill_2
XFILLER_101_682 VPWR VGND sg13g2_decap_4
XFILLER_74_599 VPWR VGND sg13g2_fill_1
XFILLER_61_205 VPWR VGND sg13g2_fill_1
XFILLER_70_761 VPWR VGND sg13g2_decap_8
XFILLER_14_165 VPWR VGND sg13g2_decap_8
XFILLER_116_708 VPWR VGND sg13g2_decap_8
Xclkbuf_leaf_4_clk_i _9672_/CLK clkbuf_leaf_9_clk_i/A VPWR VGND sg13g2_buf_16
XFILLER_109_771 VPWR VGND sg13g2_decap_8
X_5961_ _9322_/D _5960_/B _5959_/Y _5960_/Y VPWR VGND sg13g2_o21ai_1
XFILLER_65_588 VPWR VGND sg13g2_decap_8
XFILLER_46_780 VPWR VGND sg13g2_fill_1
X_7700_ _7700_/Y _9075_/Q _7705_/B _7705_/A VPWR VGND sg13g2_nand3b_1
X_8680_ _8680_/Q _9630_/CLK _8680_/D fanout943/X VPWR VGND sg13g2_dfrbpq_1
X_4912_ _4912_/X _4913_/A _4999_/B _4998_/B VPWR VGND sg13g2_and3_1
XFILLER_45_290 VPWR VGND sg13g2_decap_8
X_5892_ _5892_/Y _5939_/A _5889_/X _5933_/C VPWR VGND sg13g2_o21ai_1
X_7631_ _7631_/Y _9009_/Q _7775_/C _7630_/Y VPWR VGND sg13g2_o21ai_1
XFILLER_60_260 VPWR VGND sg13g2_fill_2
XFILLER_20_113 VPWR VGND sg13g2_decap_8
XFILLER_21_625 VPWR VGND sg13g2_decap_8
XFILLER_21_647 VPWR VGND sg13g2_fill_1
X_4843_ _4959_/B _4827_/A _4903_/D _4925_/A2 VPWR VGND sg13g2_a21o_1
X_4774_ _4774_/Y _4842_/A _4776_/B VPWR VGND sg13g2_nand2b_1
X_7562_ _7565_/A _7834_/A _7834_/B _9099_/Q VPWR VGND sg13g2_nor3_1
Xclkbuf_leaf_9_jtag_tck_i_regs _9449_/CLK clkbuf_leaf_9_jtag_tck_i_regs/A VPWR VGND
+ sg13g2_buf_16
X_9301_ _9301_/Q _9304_/CLK _9301_/D place2410/X VPWR VGND sg13g2_dfrbpq_1
X_7493_ _7494_/D _9188_/Q _7485_/B _7489_/A VPWR VGND sg13g2_o21ai_1
X_6513_ _9406_/D _6511_/Y _6432_/S _6512_/Y VPWR VGND sg13g2_a21oi_1
X_9232_ _9232_/Q _9242_/CLK _9232_/D place2494/X VPWR VGND sg13g2_dfrbpq_1
X_6444_ _6444_/Y _9197_/Q _6507_/A2 _6506_/B1 _9073_/Q VPWR VGND sg13g2_a22oi_1
XFILLER_115_741 VPWR VGND sg13g2_fill_2
X_9163_ _9163_/Q clkload6/A _9163_/D place2435/X VPWR VGND sg13g2_dfrbpq_1
X_6375_ _6375_/Y _8870_/Q _6375_/A2 _6374_/X _6129_/A VPWR VGND sg13g2_a22oi_1
XFILLER_115_774 VPWR VGND sg13g2_fill_2
X_5326_ _5330_/A _5325_/Y _5254_/C _5339_/C VPWR VGND sg13g2_o21ai_1
X_8114_ _9057_/D _8120_/A1 _8034_/Y _8113_/Y VPWR VGND sg13g2_o21ai_1
XFILLER_0_507 VPWR VGND sg13g2_fill_1
X_9094_ _9094_/Q _9188_/CLK _9094_/D place2474/X VPWR VGND sg13g2_dfrbpq_1
XFILLER_88_647 VPWR VGND sg13g2_decap_8
X_5257_ _8770_/D _5288_/A1 _5362_/C _5256_/Y _5288_/B2 VPWR VGND sg13g2_a22oi_1
X_8045_ _9030_/D _8054_/A1 _7909_/Y _8044_/Y VPWR VGND sg13g2_o21ai_1
XFILLER_102_479 VPWR VGND sg13g2_decap_8
XFILLER_96_680 VPWR VGND sg13g2_decap_8
X_5188_ _5190_/B _5188_/A _5188_/B _5188_/C VPWR VGND sg13g2_nand3_1
XFILLER_113_34 VPWR VGND sg13g2_decap_8
XFILLER_83_330 VPWR VGND sg13g2_fill_2
X_8947_ _8947_/Q _9615_/CLK _8947_/D place2418/X VPWR VGND sg13g2_dfrbpq_1
XFILLER_71_558 VPWR VGND sg13g2_fill_2
XFILLER_37_791 VPWR VGND sg13g2_fill_2
X_8878_ _8878_/Q _9253_/CLK _8878_/D place2477/X VPWR VGND sg13g2_dfrbpq_1
X_9497__2883 _9497_/RESET_B VPWR VGND sg13g2_tiehi
Xinput2600 _5851_/B1 master_rdata_i[2] VPWR VGND sg13g2_buf_1
X_7829_ _7829_/Y _7829_/A _7829_/B VPWR VGND sg13g2_nor2_1
XFILLER_8_607 VPWR VGND sg13g2_fill_2
Xinput2622 _7036_/B slave_be_i[0] VPWR VGND sg13g2_buf_1
Xinput2611 _6033_/B slave_addr_i[10] VPWR VGND sg13g2_buf_1
Xinput2633 _7198_/A slave_wdata_i[19] VPWR VGND sg13g2_buf_1
Xinput2655 _6962_/B slave_we_i VPWR VGND sg13g2_buf_1
Xinput2644 _7232_/B slave_wdata_i[29] VPWR VGND sg13g2_buf_1
XFILLER_106_741 VPWR VGND sg13g2_decap_8
XFILLER_98_46 VPWR VGND sg13g2_decap_4
XFILLER_106_774 VPWR VGND sg13g2_decap_8
XFILLER_79_625 VPWR VGND sg13g2_decap_8
XFILLER_120_210 VPWR VGND sg13g2_fill_1
XFILLER_105_295 VPWR VGND sg13g2_decap_8
XFILLER_78_135 VPWR VGND sg13g2_decap_8
XFILLER_120_276 VPWR VGND sg13g2_decap_8
XFILLER_19_246 VPWR VGND sg13g2_fill_2
XFILLER_62_503 VPWR VGND sg13g2_fill_2
XFILLER_15_430 VPWR VGND sg13g2_decap_4
XFILLER_15_463 VPWR VGND sg13g2_decap_4
XFILLER_42_260 VPWR VGND sg13g2_decap_8
Xplace2007 _6546_/D _6951_/B VPWR VGND sg13g2_buf_1
XFILLER_11_680 VPWR VGND sg13g2_decap_8
XFILLER_7_651 VPWR VGND sg13g2_decap_4
XFILLER_7_640 VPWR VGND sg13g2_decap_4
Xplace2018 _7221_/D _7179_/D VPWR VGND sg13g2_buf_1
Xplace2029 _6655_/B2 _6669_/B2 VPWR VGND sg13g2_buf_1
X_4490_ _4491_/B _9637_/Q _9636_/Q VPWR VGND sg13g2_nand2b_1
XFILLER_116_549 VPWR VGND sg13g2_decap_4
X_6160_ _6161_/C _6408_/B _6438_/A _6323_/C _6160_/D VPWR VGND sg13g2_nand4_1
XFILLER_97_422 VPWR VGND sg13g2_fill_1
X_5111_ _5114_/B _5175_/B _5111_/B _5147_/D _5117_/D VPWR VGND sg13g2_nand4_1
XFILLER_88_90 VPWR VGND sg13g2_fill_2
XFILLER_112_766 VPWR VGND sg13g2_decap_4
XFILLER_85_606 VPWR VGND sg13g2_fill_1
X_6091_ _6092_/B _9234_/Q _6247_/C VPWR VGND sg13g2_nand2b_1
XFILLER_112_799 VPWR VGND sg13g2_fill_2
X_5042_ _5147_/B _5177_/A _5160_/B VPWR VGND sg13g2_nor2_1
XFILLER_57_319 VPWR VGND sg13g2_decap_8
XFILLER_38_544 VPWR VGND sg13g2_decap_8
XFILLER_93_683 VPWR VGND sg13g2_decap_8
X_8801_ _8801_/Q _9304_/CLK _8801_/D place2407/X VPWR VGND sg13g2_dfrbpq_1
XFILLER_53_514 VPWR VGND sg13g2_fill_2
XFILLER_38_588 VPWR VGND sg13g2_fill_1
XFILLER_92_182 VPWR VGND sg13g2_fill_1
X_6993_ _6993_/Y _6987_/Y _6992_/Y _8095_/D VPWR VGND sg13g2_o21ai_1
X_5944_ _9319_/D _5981_/B _5942_/Y _5943_/Y VPWR VGND sg13g2_o21ai_1
X_8732_ _8733_/D _9153_/CLK _8732_/D place2440/X VPWR VGND sg13g2_dfrbpq_1
X_5875_ _5875_/Y _5891_/A1 _5930_/A2 _5875_/B1 _5891_/B2 VPWR VGND sg13g2_a22oi_1
XFILLER_80_388 VPWR VGND sg13g2_decap_8
X_8663_ _8663_/Q _8663_/CLK _8663_/D input2574/X VPWR VGND sg13g2_dfrbpq_1
XFILLER_34_794 VPWR VGND sg13g2_fill_2
X_7614_ _7615_/D _8802_/Q _7808_/B1 _5177_/A _7551_/B VPWR VGND sg13g2_a22oi_1
X_8594_ _8594_/Q _8678_/CLK _8594_/D fanout947/X VPWR VGND sg13g2_dfrbpq_1
XFILLER_21_444 VPWR VGND sg13g2_fill_1
X_4826_ _4826_/Y _4880_/D _4937_/C VPWR VGND sg13g2_nand2_1
X_7545_ _7548_/A _7651_/A _9129_/Q _7650_/C VPWR VGND sg13g2_nor3_1
X_4757_ _4757_/Y _8818_/Q _9346_/Q VPWR VGND sg13g2_nand2b_1
X_4688_ _4688_/Y _8743_/Q _9661_/Q _6954_/S _4683_/Y VPWR VGND sg13g2_a22oi_1
XFILLER_107_516 VPWR VGND sg13g2_decap_4
Xplace2530 _6514_/S1 _6480_/S1 VPWR VGND sg13g2_buf_1
X_7476_ _7476_/X _7476_/A _7476_/B _7476_/C VPWR VGND sg13g2_and3_1
XFILLER_108_34 VPWR VGND sg13g2_fill_2
X_9215_ _9215_/Q _9219_/CLK _9215_/D place2409/X VPWR VGND sg13g2_dfrbpq_1
X_6427_ _6427_/Y _6504_/A1 _6463_/A2 _6427_/B1 VPWR VGND sg13g2_a21oi_1
XFILLER_122_519 VPWR VGND sg13g2_decap_4
Xplace1862 _8579_/A2 _8587_/A2 VPWR VGND sg13g2_buf_1
Xplace1851 _6904_/S _8503_/B VPWR VGND sg13g2_buf_1
Xplace1840 _7950_/A _7934_/A VPWR VGND sg13g2_buf_1
X_6358_ _6358_/X _8994_/Q _9056_/Q _9118_/Q _9180_/Q _6381_/S0 _6363_/S1 VPWR VGND
+ sg13g2_mux4_1
X_9146_ _9146_/Q clkload5/A _9146_/D place2498/X VPWR VGND sg13g2_dfrbpq_1
Xhold3221 _6634_/A _9442_/Q VPWR VGND sg13g2_dlygate4sd3_1
XFILLER_115_571 VPWR VGND sg13g2_fill_2
X_5309_ _8778_/D _5341_/A1 _8439_/A2 _5308_/Y _5336_/B2 VPWR VGND sg13g2_a22oi_1
Xplace1873 _7885_/S _7884_/S VPWR VGND sg13g2_buf_1
Xhold3210 _8215_/A _9108_/Q VPWR VGND sg13g2_dlygate4sd3_1
Xplace1895 _6756_/S _6785_/S VPWR VGND sg13g2_buf_1
Xplace1884 _7129_/C _7105_/C VPWR VGND sg13g2_buf_1
XFILLER_0_337 VPWR VGND sg13g2_fill_2
Xhold3232 _8189_/A _9095_/Q VPWR VGND sg13g2_dlygate4sd3_1
XFILLER_102_243 VPWR VGND sg13g2_fill_1
X_9077_ _9077_/Q _9198_/CLK _9077_/D place2439/X VPWR VGND sg13g2_dfrbpq_1
Xhold3243 _4398_/B1 _8673_/Q VPWR VGND sg13g2_dlygate4sd3_1
XFILLER_0_359 VPWR VGND sg13g2_decap_8
X_6289_ _6289_/Y _6328_/C _6328_/A _6289_/B1 VPWR VGND sg13g2_a21oi_1
XFILLER_76_628 VPWR VGND sg13g2_decap_8
XFILLER_75_127 VPWR VGND sg13g2_decap_8
X_8028_ _8028_/Y _8028_/A _8099_/B VPWR VGND sg13g2_nand2_1
XFILLER_48_319 VPWR VGND sg13g2_fill_2
XFILLER_29_533 VPWR VGND sg13g2_decap_8
XFILLER_83_160 VPWR VGND sg13g2_fill_1
XFILLER_29_566 VPWR VGND sg13g2_decap_4
XFILLER_83_193 VPWR VGND sg13g2_decap_8
XFILLER_25_750 VPWR VGND sg13g2_decap_8
XFILLER_52_580 VPWR VGND sg13g2_fill_1
XFILLER_25_772 VPWR VGND sg13g2_fill_2
XFILLER_40_731 VPWR VGND sg13g2_decap_8
XFILLER_8_415 VPWR VGND sg13g2_decap_8
XFILLER_33_85 VPWR VGND sg13g2_decap_8
XFILLER_123_0 VPWR VGND sg13g2_decap_8
XFILLER_8_459 VPWR VGND sg13g2_decap_8
XFILLER_4_621 VPWR VGND sg13g2_decap_8
XFILLER_3_120 VPWR VGND sg13g2_fill_1
XFILLER_3_153 VPWR VGND sg13g2_decap_8
XFILLER_121_552 VPWR VGND sg13g2_fill_1
XFILLER_94_436 VPWR VGND sg13g2_decap_8
XFILLER_79_477 VPWR VGND sg13g2_fill_2
XFILLER_47_374 VPWR VGND sg13g2_decap_8
XFILLER_90_642 VPWR VGND sg13g2_decap_4
XFILLER_74_193 VPWR VGND sg13g2_decap_4
XFILLER_74_171 VPWR VGND sg13g2_decap_8
Xclkbuf_leaf_22_clk_i _9407_/CLK clkload1/A VPWR VGND sg13g2_buf_16
XFILLER_50_528 VPWR VGND sg13g2_decap_8
XFILLER_22_219 VPWR VGND sg13g2_decap_4
XFILLER_31_720 VPWR VGND sg13g2_fill_2
X_5660_ _5662_/A _5660_/A _5660_/B VPWR VGND sg13g2_nor2_1
XFILLER_90_91 VPWR VGND sg13g2_decap_4
X_4611_ _4614_/D _9676_/Q _8737_/Q VPWR VGND sg13g2_nor2b_1
XFILLER_31_775 VPWR VGND sg13g2_decap_4
X_5591_ _5591_/Y _6660_/A _5591_/B VPWR VGND sg13g2_nand2_1
XFILLER_30_296 VPWR VGND sg13g2_fill_1
X_4542_ _4542_/Y _7735_/A _7735_/B _5400_/A _7004_/C VPWR VGND sg13g2_nor4_1
X_7330_ _7330_/Y _7330_/A _7330_/B _7330_/C _7330_/D VPWR VGND sg13g2_nor4_1
X_4473_ _9669_/D _8740_/Q _9669_/Q _4708_/A VPWR VGND sg13g2_or3_1
X_7261_ _7265_/B _8784_/Q _7301_/B _7579_/A2 _8833_/Q VPWR VGND sg13g2_a22oi_1
X_6212_ _6212_/Y _8850_/Q _7229_/B2 _6211_/X _6434_/A2 VPWR VGND sg13g2_a22oi_1
X_9000_ _9000_/Q clkload4/A _9000_/D place2482/X VPWR VGND sg13g2_dfrbpq_1
X_7192_ _7192_/Y _8483_/A2 _7222_/A2 _7191_/Y VPWR VGND sg13g2_o21ai_1
Xfanout939 _5933_/C _5954_/C VPWR VGND sg13g2_buf_1
XFILLER_97_252 VPWR VGND sg13g2_decap_4
X_6143_ _6144_/C _6224_/A _8474_/B _6369_/D _6143_/D VPWR VGND sg13g2_nand4_1
X_6074_ _9345_/D _6131_/D _6073_/X _6069_/Y VPWR VGND sg13g2_a21oi_1
X_5025_ _5025_/Y _5159_/C _5024_/Y _5115_/D VPWR VGND sg13g2_o21ai_1
XFILLER_54_18 VPWR VGND sg13g2_decap_8
XFILLER_53_355 VPWR VGND sg13g2_decap_8
XFILLER_26_558 VPWR VGND sg13g2_decap_8
X_6976_ _7239_/S _7218_/B _6962_/Y _6974_/Y VPWR VGND sg13g2_o21ai_1
X_8715_ _8715_/Q _9662_/CLK _8715_/D place2446/X VPWR VGND sg13g2_dfrbpq_1
X_5927_ _9317_/D _5926_/Y _5837_/Y _5920_/Y VPWR VGND sg13g2_o21ai_1
XFILLER_53_399 VPWR VGND sg13g2_fill_1
XFILLER_13_208 VPWR VGND sg13g2_decap_4
X_9695_ _9695_/Q _9708_/CLK _9695_/D fanout954/X VPWR VGND sg13g2_dfrbpq_1
X_8646_ _8646_/Q _9449_/CLK _8646_/D fanout971/X VPWR VGND sg13g2_dfrbpq_1
X_5858_ _5858_/Y _5890_/A _5890_/B _5921_/A _5890_/D VPWR VGND sg13g2_nand4_1
X_5789_ _9287_/D _5789_/A VPWR VGND sg13g2_inv_1
X_8577_ _8577_/Y _8577_/A _8577_/B _9281_/Q VPWR VGND sg13g2_nand3_1
X_4809_ _4816_/C _4814_/B _4924_/B VPWR VGND sg13g2_nor2_1
X_7528_ _7528_/Y _9066_/Q _7608_/B _7820_/A VPWR VGND sg13g2_nand3b_1
X_7459_ _7459_/Y _7459_/A _7458_/Y VPWR VGND sg13g2_nor2b_1
Xplace2360 _8517_/C _8426_/C VPWR VGND sg13g2_buf_1
Xplace2382 _6959_/B _9221_/D VPWR VGND sg13g2_buf_1
Xplace2371 _8448_/C _5203_/A VPWR VGND sg13g2_buf_1
Xplace2393 place2393/X place2394/X VPWR VGND sg13g2_buf_1
XFILLER_0_101 VPWR VGND sg13g2_decap_8
XFILLER_95_14 VPWR VGND sg13g2_fill_2
Xhold3051 _8327_/A _9164_/Q VPWR VGND sg13g2_dlygate4sd3_1
Xhold3040 _8267_/A _9134_/Q VPWR VGND sg13g2_dlygate4sd3_1
X_9129_ _9129_/Q _9254_/CLK _9129_/D place2457/X VPWR VGND sg13g2_dfrbpq_1
XFILLER_1_646 VPWR VGND sg13g2_decap_8
Xhold3084 _8273_/A _9137_/Q VPWR VGND sg13g2_dlygate4sd3_1
XFILLER_0_167 VPWR VGND sg13g2_fill_1
XFILLER_0_156 VPWR VGND sg13g2_decap_4
Xhold3062 _8464_/B _9237_/Q VPWR VGND sg13g2_dlygate4sd3_1
Xhold3073 _8259_/A _9130_/Q VPWR VGND sg13g2_dlygate4sd3_1
Xhold3095 _5687_/B2 _8597_/Q VPWR VGND sg13g2_dlygate4sd3_1
XFILLER_29_341 VPWR VGND sg13g2_decap_8
XFILLER_29_363 VPWR VGND sg13g2_fill_2
XFILLER_84_491 VPWR VGND sg13g2_decap_4
XFILLER_84_480 VPWR VGND sg13g2_decap_4
XFILLER_17_514 VPWR VGND sg13g2_decap_8
XFILLER_17_525 VPWR VGND sg13g2_fill_1
XFILLER_72_642 VPWR VGND sg13g2_decap_8
XFILLER_71_130 VPWR VGND sg13g2_fill_1
XFILLER_32_539 VPWR VGND sg13g2_fill_2
XFILLER_71_196 VPWR VGND sg13g2_fill_2
XFILLER_13_742 VPWR VGND sg13g2_decap_8
XFILLER_25_580 VPWR VGND sg13g2_fill_1
XFILLER_9_757 VPWR VGND sg13g2_decap_8
XFILLER_8_245 VPWR VGND sg13g2_decap_8
XFILLER_60_61 VPWR VGND sg13g2_decap_8
XFILLER_4_473 VPWR VGND sg13g2_decap_8
XFILLER_106_390 VPWR VGND sg13g2_decap_8
XFILLER_82_406 VPWR VGND sg13g2_decap_8
XFILLER_48_650 VPWR VGND sg13g2_decap_8
XFILLER_47_182 VPWR VGND sg13g2_decap_4
X_6830_ _9578_/D _9611_/Q _9578_/Q _6834_/S VPWR VGND sg13g2_mux2_1
XFILLER_63_664 VPWR VGND sg13g2_decap_4
XFILLER_62_130 VPWR VGND sg13g2_decap_8
X_6761_ _9520_/D _9520_/Q _9430_/Q _6781_/S VPWR VGND sg13g2_mux2_1
XFILLER_62_174 VPWR VGND sg13g2_fill_1
XFILLER_50_314 VPWR VGND sg13g2_decap_8
X_5712_ _5712_/X _5716_/A _9309_/Q _5716_/C VPWR VGND sg13g2_and3_1
X_8500_ _8502_/B _8501_/A _8500_/B _8500_/C _8740_/D VPWR VGND sg13g2_nor4_1
XFILLER_50_358 VPWR VGND sg13g2_decap_8
XFILLER_50_336 VPWR VGND sg13g2_decap_8
X_6692_ _6692_/Y _6692_/A _6692_/B _6692_/C _6692_/D VPWR VGND sg13g2_nand4_1
X_9480_ _9480_/Q _9603_/CLK _9480_/D _9480_/RESET_B VPWR VGND sg13g2_dfrbpq_1
X_8431_ _9219_/D _5275_/Y _8430_/A _8430_/Y VPWR VGND sg13g2_o21ai_1
X_5643_ _5643_/Y _5643_/A _5643_/B VPWR VGND sg13g2_nor2_1
X_5574_ _5574_/Y _9444_/Q _5570_/B _5580_/B1 _8646_/Q VPWR VGND sg13g2_a22oi_1
X_8362_ _9181_/D _5349_/C _8383_/A _8361_/Y VPWR VGND sg13g2_o21ai_1
X_4525_ _8816_/D _4525_/A _4525_/B VPWR VGND sg13g2_nor2_1
X_7313_ _7313_/Y _7313_/A _7313_/B _7313_/C _7313_/D VPWR VGND sg13g2_nor4_1
XFILLER_117_677 VPWR VGND sg13g2_decap_8
XFILLER_116_143 VPWR VGND sg13g2_decap_8
X_8293_ _8293_/Y _8293_/A _8347_/B VPWR VGND sg13g2_nand2_1
Xclkbuf_3_1__f_clk_i clkload0/A clkbuf_0_clk_i/X VPWR VGND sg13g2_buf_8
X_7244_ _7244_/Y _7244_/A _7245_/C _7244_/C _7244_/D VPWR VGND sg13g2_nor4_1
X_4456_ _9690_/D _6071_/A _5394_/B _4456_/C VPWR VGND sg13g2_nor3_1
X_9611__2779 _9611_/RESET_B VPWR VGND sg13g2_tiehi
X_4387_ _4387_/Y _5628_/B _4591_/B _4389_/B VPWR VGND sg13g2_o21ai_1
X_7175_ _7175_/Y _7187_/A _7175_/B _7236_/C _7182_/D VPWR VGND sg13g2_nand4_1
XFILLER_58_425 VPWR VGND sg13g2_fill_2
X_6126_ _6126_/Y _6079_/A _6438_/D _6397_/A _6332_/C _6113_/Y VPWR VGND sg13g2_a221oi_1
XFILLER_86_767 VPWR VGND sg13g2_decap_8
XFILLER_86_789 VPWR VGND sg13g2_fill_1
XFILLER_86_778 VPWR VGND sg13g2_fill_2
XFILLER_85_255 VPWR VGND sg13g2_fill_2
X_6057_ _6057_/Y _6373_/A1 _6373_/A2 _6057_/B1 VPWR VGND sg13g2_a21oi_1
XFILLER_100_588 VPWR VGND sg13g2_fill_2
X_5008_ _5008_/Y _5008_/A _9374_/Q VPWR VGND sg13g2_nor2b_1
XFILLER_39_683 VPWR VGND sg13g2_decap_8
XFILLER_54_664 VPWR VGND sg13g2_decap_4
XFILLER_38_193 VPWR VGND sg13g2_decap_8
XFILLER_14_528 VPWR VGND sg13g2_decap_8
XFILLER_14_539 VPWR VGND sg13g2_fill_2
X_6959_ _6959_/Y _7132_/D _6959_/B VPWR VGND sg13g2_nand2_1
X_9678_ _9678_/Q _9678_/CLK _9678_/D fanout965/X VPWR VGND sg13g2_dfrbpq_1
XFILLER_10_701 VPWR VGND sg13g2_decap_8
XFILLER_41_369 VPWR VGND sg13g2_decap_8
X_8629_ _8629_/Q _9678_/CLK _8629_/D fanout968/X VPWR VGND sg13g2_dfrbpq_1
XFILLER_10_712 VPWR VGND sg13g2_decap_8
XFILLER_22_572 VPWR VGND sg13g2_fill_1
XFILLER_5_237 VPWR VGND sg13g2_fill_1
XFILLER_123_603 VPWR VGND sg13g2_decap_8
XFILLER_108_688 VPWR VGND sg13g2_decap_8
Xplace2190 _7029_/A _7025_/A VPWR VGND sg13g2_buf_1
XFILLER_30_86 VPWR VGND sg13g2_fill_2
XFILLER_110_308 VPWR VGND sg13g2_fill_1
XFILLER_49_458 VPWR VGND sg13g2_decap_8
XFILLER_64_406 VPWR VGND sg13g2_decap_8
XFILLER_64_428 VPWR VGND sg13g2_decap_8
XFILLER_45_653 VPWR VGND sg13g2_decap_8
XFILLER_60_612 VPWR VGND sg13g2_decap_8
XFILLER_32_347 VPWR VGND sg13g2_fill_2
XFILLER_13_572 VPWR VGND sg13g2_decap_4
XFILLER_113_102 VPWR VGND sg13g2_decap_4
X_4310_ _5086_/A _9261_/Q VPWR VGND sg13g2_inv_1
X_5290_ _5329_/B _9881_/A _5291_/B _5290_/C _5291_/D VPWR VGND sg13g2_and4_1
XFILLER_68_712 VPWR VGND sg13g2_decap_4
XFILLER_95_564 VPWR VGND sg13g2_decap_8
XFILLER_67_266 VPWR VGND sg13g2_decap_8
X_8980_ _8980_/Q clkload7/A _8980_/D place2464/X VPWR VGND sg13g2_dfrbpq_1
X_7931_ _8977_/D _5362_/C _7956_/A _7930_/Y VPWR VGND sg13g2_o21ai_1
XFILLER_24_804 VPWR VGND sg13g2_fill_1
X_9601_ _9601_/Q _9621_/CLK _9601_/D _9601_/RESET_B VPWR VGND sg13g2_dfrbpq_1
X_7862_ _8937_/D _7438_/Y _8514_/B _7861_/Y VPWR VGND sg13g2_a21oi_1
XFILLER_35_163 VPWR VGND sg13g2_fill_1
X_7793_ _8923_/D _8923_/Q _7792_/Y _7793_/S VPWR VGND sg13g2_mux2_1
X_6813_ _9561_/D _9594_/Q _9561_/Q _6813_/S VPWR VGND sg13g2_mux2_1
XFILLER_51_645 VPWR VGND sg13g2_decap_4
XFILLER_35_185 VPWR VGND sg13g2_fill_2
X_9532_ _9532_/Q _9582_/CLK _9532_/D _9532_/RESET_B VPWR VGND sg13g2_dfrbpq_1
X_6744_ _6745_/D _6741_/Y _6742_/Y _6743_/Y VPWR VGND sg13g2_o21ai_1
X_9463_ _9463_/Q _9675_/CLK _9463_/D place2449/X VPWR VGND sg13g2_dfrbpq_1
X_6675_ _9454_/D _8605_/Q _4458_/X _5494_/A _5494_/B _6951_/B VPWR VGND sg13g2_a221oi_1
X_8414_ _8414_/Y _8428_/A _9211_/Q _8414_/C VPWR VGND sg13g2_nand3_1
X_5626_ _5631_/A _8619_/Q _5660_/B VPWR VGND sg13g2_nor2_1
X_9394_ _9394_/Q _9406_/CLK _9394_/D place2489/X VPWR VGND sg13g2_dfrbpq_1
X_5557_ _8640_/D _5556_/Y _5555_/Y _5587_/B1 VPWR VGND sg13g2_a21oi_1
X_8345_ _8345_/Y _8345_/A _8345_/B VPWR VGND sg13g2_nand2_1
XFILLER_3_708 VPWR VGND sg13g2_decap_8
X_4508_ _7004_/A _4513_/C _9504_/Q VPWR VGND sg13g2_nand2_1
X_5488_ _5492_/A _9555_/Q _8726_/Q VPWR VGND sg13g2_and2_1
X_8276_ _9138_/D _8288_/A1 _8086_/Y _8275_/Y VPWR VGND sg13g2_o21ai_1
X_7227_ _8891_/D _7226_/Y _8891_/Q _7239_/S VPWR VGND sg13g2_mux2_1
X_4439_ _4440_/B _7162_/A _7158_/A _7168_/B _7165_/A VPWR VGND sg13g2_nor4_1
XFILLER_120_617 VPWR VGND sg13g2_fill_1
XFILLER_120_606 VPWR VGND sg13g2_decap_8
XFILLER_76_27 VPWR VGND sg13g2_fill_2
XFILLER_59_745 VPWR VGND sg13g2_fill_2
X_7158_ _7158_/Y _7158_/A _7172_/B _7207_/C _7179_/D VPWR VGND sg13g2_nand4_1
XFILLER_58_244 VPWR VGND sg13g2_decap_8
X_6109_ _6109_/Y _8837_/Q _6130_/B _6108_/X _6390_/A2 _6392_/S VPWR VGND sg13g2_a221oi_1
X_7089_ _8849_/D _7088_/Y _8849_/Q _7110_/S VPWR VGND sg13g2_mux2_1
XFILLER_100_363 VPWR VGND sg13g2_fill_2
XFILLER_73_236 VPWR VGND sg13g2_decap_8
XFILLER_92_37 VPWR VGND sg13g2_fill_2
XFILLER_27_664 VPWR VGND sg13g2_fill_2
XFILLER_41_100 VPWR VGND sg13g2_fill_1
XFILLER_41_133 VPWR VGND sg13g2_fill_1
XFILLER_10_542 VPWR VGND sg13g2_decap_8
XFILLER_6_579 VPWR VGND sg13g2_fill_2
XFILLER_89_391 VPWR VGND sg13g2_decap_8
XFILLER_2_35 VPWR VGND sg13g2_decap_8
XFILLER_92_501 VPWR VGND sg13g2_fill_1
XFILLER_92_523 VPWR VGND sg13g2_decap_8
XFILLER_92_545 VPWR VGND sg13g2_decap_8
XFILLER_18_664 VPWR VGND sg13g2_decap_8
XFILLER_32_100 VPWR VGND sg13g2_decap_4
XFILLER_33_645 VPWR VGND sg13g2_decap_8
XFILLER_60_442 VPWR VGND sg13g2_decap_8
X_4790_ _4945_/B _4791_/B _4791_/C VPWR VGND sg13g2_nor2_1
XFILLER_118_205 VPWR VGND sg13g2_fill_1
X_6460_ _6460_/Y _6161_/A _6459_/Y _6171_/Y VPWR VGND sg13g2_a21oi_1
X_5411_ _8747_/D _5410_/Y _5395_/B _7132_/B VPWR VGND sg13g2_a21oi_1
X_6391_ _6391_/Y _6114_/Y _6176_/Y _6390_/Y VPWR VGND sg13g2_o21ai_1
X_5342_ _7730_/C _7431_/A _7544_/B VPWR VGND sg13g2_nor2_1
X_8130_ _9065_/D _8130_/A1 _8056_/Y _8129_/Y VPWR VGND sg13g2_o21ai_1
X_8061_ _8061_/Y _8061_/A _9486_/Q _8498_/D _8083_/D VPWR VGND sg13g2_nand4_1
XFILLER_49_0 VPWR VGND sg13g2_decap_8
XFILLER_101_105 VPWR VGND sg13g2_decap_8
X_7012_ _8826_/D _5337_/Y _8003_/A _7011_/Y VPWR VGND sg13g2_o21ai_1
X_5273_ _5273_/Y _5273_/A _5273_/B VPWR VGND sg13g2_nand2_1
Xhold2927 _8721_/D _8720_/Q VPWR VGND sg13g2_dlygate4sd3_1
Xhold2938 _4580_/B _9704_/Q VPWR VGND sg13g2_dlygate4sd3_1
XFILLER_68_564 VPWR VGND sg13g2_decap_8
Xhold2949 _6156_/B1 _9353_/Q VPWR VGND sg13g2_dlygate4sd3_1
XFILLER_28_428 VPWR VGND sg13g2_fill_1
X_8963_ _8963_/Q clkload5/A _8963_/D place2497/X VPWR VGND sg13g2_dfrbpq_1
XFILLER_64_781 VPWR VGND sg13g2_decap_4
X_8894_ _8894_/Q _9253_/CLK _8894_/D place2487/X VPWR VGND sg13g2_dfrbpq_1
X_7914_ _8970_/D _5355_/C _7917_/A _7913_/Y VPWR VGND sg13g2_o21ai_1
X_7845_ _7845_/Y _7845_/A _7845_/B _7845_/C VPWR VGND sg13g2_nand3_1
XFILLER_23_100 VPWR VGND sg13g2_fill_1
XFILLER_24_623 VPWR VGND sg13g2_decap_8
X_7776_ _7780_/A _7783_/C _9141_/Q _7802_/C VPWR VGND sg13g2_nor3_1
X_9515_ _9515_/Q _9686_/CLK _9515_/D _9515_/RESET_B VPWR VGND sg13g2_dfrbpq_1
X_4988_ _4989_/D _4844_/B _4898_/C _4914_/B VPWR VGND sg13g2_o21ai_1
X_6727_ _9495_/D _9536_/Q _9495_/Q _6736_/S VPWR VGND sg13g2_mux2_1
X_9446_ _9446_/Q _9567_/CLK _9446_/D fanout980/X VPWR VGND sg13g2_dfrbpq_1
X_6658_ _6658_/Y _6661_/C _8651_/Q _9583_/Q _6669_/B2 VPWR VGND sg13g2_a22oi_1
XFILLER_118_750 VPWR VGND sg13g2_decap_8
X_9377_ _9377_/Q _9692_/CLK _9377_/D place2502/X VPWR VGND sg13g2_dfrbpq_1
X_5609_ _5609_/Y _5609_/A _5621_/B VPWR VGND sg13g2_nand2_1
X_8328_ _9164_/D _8346_/A1 _8071_/Y _8327_/Y VPWR VGND sg13g2_o21ai_1
X_6589_ _6589_/Y _8630_/Q _5478_/Y _6588_/X VPWR VGND sg13g2_o21ai_1
XFILLER_11_44 VPWR VGND sg13g2_decap_8
XFILLER_3_527 VPWR VGND sg13g2_fill_2
XFILLER_3_516 VPWR VGND sg13g2_decap_8
X_8259_ _8259_/Y _8259_/A _8287_/B VPWR VGND sg13g2_nand2_1
XFILLER_120_469 VPWR VGND sg13g2_decap_8
XFILLER_86_394 VPWR VGND sg13g2_fill_2
XFILLER_62_707 VPWR VGND sg13g2_fill_1
XFILLER_55_781 VPWR VGND sg13g2_fill_1
XFILLER_15_601 VPWR VGND sg13g2_decap_4
XFILLER_15_612 VPWR VGND sg13g2_decap_4
XFILLER_27_450 VPWR VGND sg13g2_decap_8
XFILLER_46_269 VPWR VGND sg13g2_decap_8
XFILLER_42_431 VPWR VGND sg13g2_decap_8
XFILLER_15_656 VPWR VGND sg13g2_decap_4
XFILLER_42_464 VPWR VGND sg13g2_fill_1
XFILLER_14_188 VPWR VGND sg13g2_fill_2
XFILLER_42_475 VPWR VGND sg13g2_decap_8
XFILLER_42_486 VPWR VGND sg13g2_fill_2
XFILLER_115_208 VPWR VGND sg13g2_decap_8
XFILLER_108_271 VPWR VGND sg13g2_fill_2
XFILLER_123_230 VPWR VGND sg13g2_decap_8
XFILLER_42_7 VPWR VGND sg13g2_decap_8
XFILLER_123_296 VPWR VGND sg13g2_fill_2
XFILLER_111_436 VPWR VGND sg13g2_fill_1
XFILLER_97_659 VPWR VGND sg13g2_decap_8
XFILLER_111_447 VPWR VGND sg13g2_decap_8
XFILLER_37_236 VPWR VGND sg13g2_fill_1
X_5960_ _5960_/Y _9322_/Q _5960_/B VPWR VGND sg13g2_nand2_1
XFILLER_37_269 VPWR VGND sg13g2_decap_8
X_5891_ _5891_/Y _5891_/A1 _5930_/A2 _5891_/B1 _5891_/B2 VPWR VGND sg13g2_a22oi_1
XFILLER_80_537 VPWR VGND sg13g2_decap_8
X_4911_ _4911_/Y _4907_/Y _4910_/Y _4853_/A VPWR VGND sg13g2_a21oi_1
X_7630_ _7630_/Y _7801_/A _7630_/B _7630_/C _7630_/D VPWR VGND sg13g2_nor4_1
XFILLER_60_272 VPWR VGND sg13g2_fill_1
X_4842_ _4842_/Y _4842_/A _4842_/B VPWR VGND sg13g2_nand2_1
X_4773_ _4899_/C _4983_/A _8817_/Q VPWR VGND sg13g2_nand2_1
X_7561_ _7565_/D _9192_/Q _4529_/Y _7431_/A VPWR VGND sg13g2_o21ai_1
X_9300_ _9300_/Q _9615_/CLK _9300_/D place2419/X VPWR VGND sg13g2_dfrbpq_1
X_7492_ _7494_/C _7492_/A _7492_/B _9095_/Q VPWR VGND sg13g2_nor3_1
X_6512_ _6512_/Y _6512_/A1 _6512_/A2 _6512_/B1 VPWR VGND sg13g2_a21oi_1
XFILLER_119_558 VPWR VGND sg13g2_decap_4
X_6443_ _6443_/Y _9011_/Q _6506_/A2 _6507_/B1 _9135_/Q VPWR VGND sg13g2_a22oi_1
X_9231_ _9231_/Q _9242_/CLK _9231_/D place2495/X VPWR VGND sg13g2_dfrbpq_1
X_9162_ _9162_/Q _9504_/CLK _9162_/D place2411/X VPWR VGND sg13g2_dfrbpq_1
X_6374_ _6374_/X _8996_/Q _9058_/Q _9120_/Q _9182_/Q _6377_/S0 _6381_/S1 VPWR VGND
+ sg13g2_mux4_1
X_5325_ _5325_/Y _9885_/A _9886_/A _5329_/B _5329_/C VPWR VGND sg13g2_nand4_1
X_8113_ _8113_/Y _8113_/A _8161_/B VPWR VGND sg13g2_nand2_1
X_9093_ _9093_/Q _9188_/CLK _9093_/D place2483/X VPWR VGND sg13g2_dfrbpq_1
X_5256_ _5256_/Y _5256_/A _5256_/B VPWR VGND sg13g2_nand2_1
X_8044_ _8044_/Y _8044_/A _8055_/B VPWR VGND sg13g2_nand2_1
X_5187_ _5188_/C _5187_/A _9864_/A _5187_/C _5187_/D VPWR VGND sg13g2_nand4_1
XFILLER_68_383 VPWR VGND sg13g2_fill_1
XFILLER_28_214 VPWR VGND sg13g2_decap_8
XFILLER_29_737 VPWR VGND sg13g2_decap_8
XFILLER_28_225 VPWR VGND sg13g2_fill_1
XFILLER_28_247 VPWR VGND sg13g2_decap_8
X_8946_ _8946_/Q _9611_/CLK _8946_/D place2416/X VPWR VGND sg13g2_dfrbpq_1
XFILLER_71_504 VPWR VGND sg13g2_decap_8
XFILLER_56_578 VPWR VGND sg13g2_fill_2
XFILLER_56_567 VPWR VGND sg13g2_decap_8
XFILLER_71_548 VPWR VGND sg13g2_decap_4
XFILLER_43_239 VPWR VGND sg13g2_fill_1
XFILLER_52_751 VPWR VGND sg13g2_decap_8
XFILLER_24_431 VPWR VGND sg13g2_fill_2
X_8877_ _8877_/Q _9407_/CLK _8877_/D place2477/X VPWR VGND sg13g2_dfrbpq_1
Xinput2601 _6001_/A master_rdata_i[30] VPWR VGND sg13g2_buf_1
X_7828_ _7829_/B _9303_/Q _7828_/A2 _6972_/Y _8893_/Q _7827_/Y VPWR VGND sg13g2_a221oi_1
XFILLER_12_615 VPWR VGND sg13g2_fill_1
X_7759_ _7763_/B _7759_/A _9016_/Q _7802_/C VPWR VGND sg13g2_nor3_1
Xinput2612 _8589_/A slave_addr_i[11] VPWR VGND sg13g2_buf_1
Xinput2623 _4436_/B slave_wdata_i[0] VPWR VGND sg13g2_buf_1
Xinput2634 _4436_/A slave_wdata_i[1] VPWR VGND sg13g2_buf_1
Xinput2656 _7482_/A unavailable_i VPWR VGND sg13g2_buf_1
Xinput2645 _4436_/D slave_wdata_i[2] VPWR VGND sg13g2_buf_1
X_9429_ _9429_/Q _9587_/CLK _9429_/D fanout979/X VPWR VGND sg13g2_dfrbpq_1
XFILLER_98_25 VPWR VGND sg13g2_decap_8
XFILLER_22_87 VPWR VGND sg13g2_decap_8
XFILLER_106_764 VPWR VGND sg13g2_decap_4
XFILLER_78_103 VPWR VGND sg13g2_decap_8
XFILLER_120_255 VPWR VGND sg13g2_decap_8
XFILLER_74_342 VPWR VGND sg13g2_decap_4
XFILLER_28_781 VPWR VGND sg13g2_fill_1
XFILLER_103_90 VPWR VGND sg13g2_decap_8
XFILLER_43_762 VPWR VGND sg13g2_decap_4
XFILLER_63_94 VPWR VGND sg13g2_fill_2
XFILLER_15_475 VPWR VGND sg13g2_decap_8
XFILLER_30_401 VPWR VGND sg13g2_decap_8
XFILLER_30_412 VPWR VGND sg13g2_decap_8
Xplace2019 _6839_/S _6813_/S VPWR VGND sg13g2_buf_1
Xplace2008 _6951_/B _6544_/A VPWR VGND sg13g2_buf_1
XFILLER_7_663 VPWR VGND sg13g2_decap_8
XFILLER_112_745 VPWR VGND sg13g2_fill_2
XFILLER_97_412 VPWR VGND sg13g2_fill_1
X_5110_ _5111_/B _5110_/A _5132_/B _5160_/B VPWR VGND sg13g2_nor3_1
XFILLER_69_125 VPWR VGND sg13g2_fill_1
XFILLER_69_114 VPWR VGND sg13g2_decap_8
X_6090_ _6090_/Y _6090_/A _6171_/C VPWR VGND sg13g2_nor2_1
XFILLER_112_778 VPWR VGND sg13g2_fill_1
X_5041_ _5041_/Y _5110_/A _5055_/A VPWR VGND sg13g2_nor2_1
XFILLER_97_478 VPWR VGND sg13g2_fill_2
XFILLER_85_629 VPWR VGND sg13g2_decap_8
XFILLER_84_117 VPWR VGND sg13g2_fill_1
XFILLER_111_299 VPWR VGND sg13g2_fill_2
X_8800_ _8800_/Q _9254_/CLK _8800_/D place2423/X VPWR VGND sg13g2_dfrbpq_1
XFILLER_65_342 VPWR VGND sg13g2_decap_8
XFILLER_38_567 VPWR VGND sg13g2_decap_8
X_6992_ _6992_/Y _7744_/A _6992_/B _6992_/C _6992_/D VPWR VGND sg13g2_nor4_1
X_8731_ _8731_/Q _9153_/CLK _8731_/D place2440/X VPWR VGND sg13g2_dfrbpq_1
XFILLER_19_781 VPWR VGND sg13g2_decap_4
XFILLER_25_217 VPWR VGND sg13g2_decap_8
X_5943_ _5943_/Y _9319_/Q _5981_/B VPWR VGND sg13g2_nand2_1
X_5874_ _5874_/Y _5890_/A _5890_/B _5936_/B _5890_/D VPWR VGND sg13g2_nand4_1
XFILLER_33_250 VPWR VGND sg13g2_fill_2
XFILLER_34_784 VPWR VGND sg13g2_decap_4
X_8662_ _8662_/Q _9701_/CLK _8662_/D fanout958/X VPWR VGND sg13g2_dfrbpq_1
X_7613_ _7615_/C _7613_/A1 _7846_/B1 _4293_/Y _7269_/X VPWR VGND sg13g2_a22oi_1
X_8593_ _8593_/Q _9708_/CLK _8593_/D fanout948/X VPWR VGND sg13g2_dfrbpq_1
X_4825_ _4825_/Y _4814_/Y _4913_/A _4937_/C VPWR VGND sg13g2_nand3b_1
X_7544_ _7548_/D _9160_/Q _7544_/B VPWR VGND sg13g2_nor2_1
X_4756_ _4756_/Y _4855_/A _4755_/Y _4772_/A VPWR VGND sg13g2_o21ai_1
X_4687_ _9658_/D _4687_/A _4687_/B VPWR VGND sg13g2_nor2_1
Xplace2520 _6514_/S0 _6302_/S0 VPWR VGND sg13g2_buf_1
X_7475_ _7476_/B _8795_/Q _7660_/A2 _7825_/A2 _9869_/A VPWR VGND sg13g2_a22oi_1
Xplace2531 _6480_/S1 _6349_/S1 VPWR VGND sg13g2_buf_1
X_9214_ _9214_/Q _9219_/CLK _9214_/D place2409/X VPWR VGND sg13g2_dfrbpq_1
X_6426_ _6426_/Y _8881_/Q _7229_/B2 _6425_/X _6434_/A2 VPWR VGND sg13g2_a22oi_1
Xplace1830 _8009_/A _8003_/A VPWR VGND sg13g2_buf_1
XFILLER_115_550 VPWR VGND sg13g2_fill_2
Xplace1863 _8587_/A2 _5786_/Y VPWR VGND sg13g2_buf_1
Xhold3200 _8073_/A _9041_/Q VPWR VGND sg13g2_dlygate4sd3_1
X_6357_ _6357_/Y _6438_/B _6397_/A _6039_/X VPWR VGND sg13g2_o21ai_1
XFILLER_1_806 VPWR VGND sg13g2_fill_2
X_9145_ _9145_/Q clkload5/A _9145_/D place2499/X VPWR VGND sg13g2_dfrbpq_1
Xplace1841 _7956_/A _7924_/A VPWR VGND sg13g2_buf_1
Xplace1852 _6484_/S _6319_/C1 VPWR VGND sg13g2_buf_1
XFILLER_115_583 VPWR VGND sg13g2_decap_4
Xplace1874 _7884_/S _8514_/B VPWR VGND sg13g2_buf_1
Xhold3233 _6603_/A _9433_/Q VPWR VGND sg13g2_dlygate4sd3_1
X_5308_ _5308_/Y _5308_/A _5308_/B VPWR VGND sg13g2_nand2_1
XFILLER_68_28 VPWR VGND sg13g2_decap_8
Xplace1896 _6505_/A2 _6491_/A2 VPWR VGND sg13g2_buf_1
Xhold3222 _8076_/A _9042_/Q VPWR VGND sg13g2_dlygate4sd3_1
Xhold3211 _8492_/B _9251_/Q VPWR VGND sg13g2_dlygate4sd3_1
Xplace1885 _7080_/C _7105_/C VPWR VGND sg13g2_buf_1
Xhold3244 _4669_/A1 _9643_/Q VPWR VGND sg13g2_dlygate4sd3_1
X_9076_ _9076_/Q _9501_/CLK _9076_/D place2434/X VPWR VGND sg13g2_dfrbpq_1
X_6288_ _6288_/Y _8858_/Q _6462_/A2 _6286_/X _6422_/B1 _6287_/Y VPWR VGND sg13g2_a221oi_1
X_5239_ _5291_/B _9873_/A _5243_/B _5260_/C VPWR VGND sg13g2_and3_1
X_8027_ _9023_/D _8054_/A1 _7892_/Y _8026_/Y VPWR VGND sg13g2_o21ai_1
XFILLER_29_512 VPWR VGND sg13g2_decap_8
XFILLER_75_139 VPWR VGND sg13g2_decap_8
XFILLER_84_49 VPWR VGND sg13g2_decap_4
XFILLER_56_364 VPWR VGND sg13g2_decap_8
XFILLER_44_515 VPWR VGND sg13g2_fill_2
XFILLER_83_172 VPWR VGND sg13g2_decap_8
Xclkbuf_leaf_3_clk_i _9620_/CLK clkbuf_leaf_9_clk_i/A VPWR VGND sg13g2_buf_16
XFILLER_71_312 VPWR VGND sg13g2_decap_8
XFILLER_71_301 VPWR VGND sg13g2_fill_2
XFILLER_17_54 VPWR VGND sg13g2_fill_2
X_8929_ _8929_/Q _9620_/CLK _8929_/D place2429/X VPWR VGND sg13g2_dfrbpq_1
XFILLER_71_367 VPWR VGND sg13g2_decap_8
XFILLER_71_356 VPWR VGND sg13g2_fill_1
XFILLER_71_389 VPWR VGND sg13g2_fill_2
XFILLER_12_401 VPWR VGND sg13g2_fill_1
XFILLER_40_721 VPWR VGND sg13g2_fill_1
XFILLER_52_592 VPWR VGND sg13g2_decap_8
XFILLER_24_294 VPWR VGND sg13g2_fill_2
XFILLER_12_467 VPWR VGND sg13g2_fill_2
XFILLER_40_765 VPWR VGND sg13g2_decap_8
XFILLER_12_489 VPWR VGND sg13g2_decap_4
XFILLER_8_438 VPWR VGND sg13g2_decap_8
XFILLER_116_0 VPWR VGND sg13g2_decap_8
XFILLER_3_132 VPWR VGND sg13g2_decap_8
XFILLER_79_412 VPWR VGND sg13g2_fill_1
XFILLER_79_467 VPWR VGND sg13g2_decap_4
XFILLER_121_586 VPWR VGND sg13g2_fill_2
XFILLER_58_83 VPWR VGND sg13g2_fill_1
XFILLER_75_640 VPWR VGND sg13g2_decap_8
XFILLER_75_662 VPWR VGND sg13g2_fill_1
XFILLER_47_364 VPWR VGND sg13g2_decap_4
XFILLER_47_342 VPWR VGND sg13g2_decap_4
XFILLER_74_93 VPWR VGND sg13g2_decap_8
XFILLER_62_334 VPWR VGND sg13g2_decap_4
XFILLER_50_507 VPWR VGND sg13g2_decap_8
XFILLER_16_751 VPWR VGND sg13g2_decap_8
XFILLER_15_261 VPWR VGND sg13g2_decap_4
XFILLER_16_784 VPWR VGND sg13g2_decap_8
XFILLER_15_283 VPWR VGND sg13g2_decap_8
XFILLER_31_732 VPWR VGND sg13g2_decap_8
X_4610_ _8751_/D _6519_/B _6534_/C _8563_/A VPWR VGND sg13g2_a21oi_1
XFILLER_30_253 VPWR VGND sg13g2_decap_8
X_5590_ _8651_/D _5589_/Y _5588_/Y _5593_/B1 VPWR VGND sg13g2_a21oi_1
X_4541_ _4541_/Y _7811_/A _7811_/B _8743_/D _6982_/A VPWR VGND sg13g2_nor4_1
XFILLER_116_336 VPWR VGND sg13g2_decap_4
X_4472_ _6955_/S _8728_/Q _9667_/Q VPWR VGND sg13g2_nand2b_1
X_7260_ _7265_/A _9211_/Q _7695_/A2 _7771_/A2 _9858_/A VPWR VGND sg13g2_a22oi_1
X_6211_ _6211_/X _8976_/Q _9038_/Q _9100_/Q _9162_/Q _6480_/S0 _6480_/S1 VPWR VGND
+ sg13g2_mux4_1
X_7191_ _7191_/Y _7191_/A _7210_/D _7221_/C _7221_/D VPWR VGND sg13g2_nand4_1
X_6142_ _6143_/D _6158_/A _9231_/Q VPWR VGND sg13g2_nor2b_1
XFILLER_97_220 VPWR VGND sg13g2_decap_4
XFILLER_58_607 VPWR VGND sg13g2_decap_4
X_6073_ _6073_/X _6073_/A _6073_/B VPWR VGND sg13g2_and2_1
X_5024_ _5024_/Y _5177_/A _9259_/Q VPWR VGND sg13g2_nand2_1
XFILLER_66_662 VPWR VGND sg13g2_fill_1
XFILLER_26_504 VPWR VGND sg13g2_fill_1
XFILLER_65_172 VPWR VGND sg13g2_decap_8
X_6975_ _6975_/X _7080_/C _6975_/B VPWR VGND sg13g2_or2_1
X_8714_ _8714_/Q _9662_/CLK _8714_/D place2445/X VPWR VGND sg13g2_dfrbpq_1
XFILLER_110_14 VPWR VGND sg13g2_decap_8
X_5926_ _5926_/Y _8528_/C _9482_/Q _5925_/Y VPWR VGND sg13g2_o21ai_1
XFILLER_81_687 VPWR VGND sg13g2_decap_8
XFILLER_80_164 VPWR VGND sg13g2_decap_4
X_9694_ _9694_/Q _9708_/CLK _9694_/D fanout960/X VPWR VGND sg13g2_dfrbpq_1
X_8645_ _8645_/Q _9449_/CLK _8645_/D fanout980/X VPWR VGND sg13g2_dfrbpq_1
XFILLER_22_732 VPWR VGND sg13g2_fill_1
X_5857_ _5857_/X _5992_/A _5923_/A1 _5889_/S VPWR VGND sg13g2_mux2_1
XFILLER_22_776 VPWR VGND sg13g2_decap_8
XFILLER_22_787 VPWR VGND sg13g2_fill_2
XFILLER_119_130 VPWR VGND sg13g2_fill_1
X_5788_ _5789_/A _9287_/Q _8587_/A2 _8587_/B1 _9484_/Q VPWR VGND sg13g2_a22oi_1
X_8576_ _9280_/D _5880_/Y _8563_/X _8575_/Y VPWR VGND sg13g2_o21ai_1
XFILLER_21_297 VPWR VGND sg13g2_decap_8
X_4808_ _4808_/Y _4983_/A _4807_/X _4804_/Y VPWR VGND sg13g2_a21oi_1
X_4739_ _4739_/X _6065_/A _4739_/B VPWR VGND sg13g2_or2_1
X_7527_ _7530_/C _7820_/A _7819_/B _8973_/Q VPWR VGND sg13g2_nor3_1
X_7458_ _7458_/Y _7458_/A _7458_/B _7458_/C _7458_/D VPWR VGND sg13g2_nand4_1
XFILLER_119_89 VPWR VGND sg13g2_decap_8
Xplace2361 _8426_/C _9221_/D VPWR VGND sg13g2_buf_1
Xplace2350 _8401_/C _8399_/C VPWR VGND sg13g2_buf_1
X_6409_ _6409_/Y _6371_/A _6371_/B _6409_/B1 VPWR VGND sg13g2_o21ai_1
Xplace2372 _8375_/C _8409_/C VPWR VGND sg13g2_buf_1
Xplace2383 _6507_/B1 _6404_/B1 VPWR VGND sg13g2_buf_1
Xplace2394 place2394/X place2399/X VPWR VGND sg13g2_buf_1
X_7389_ _7389_/Y _7389_/A _7389_/B _7389_/C _7389_/D VPWR VGND sg13g2_nor4_1
Xhold3041 _8115_/A _9058_/Q VPWR VGND sg13g2_dlygate4sd3_1
Xhold3030 _5654_/B _8610_/Q VPWR VGND sg13g2_dlygate4sd3_1
X_9128_ _9128_/Q clkload8/A _9128_/D place2473/X VPWR VGND sg13g2_dfrbpq_1
Xhold3074 _8021_/A _9021_/Q VPWR VGND sg13g2_dlygate4sd3_1
Xhold3063 _8167_/A _9084_/Q VPWR VGND sg13g2_dlygate4sd3_1
Xhold3052 _5689_/B2 _8598_/Q VPWR VGND sg13g2_dlygate4sd3_1
X_9059_ _9059_/Q _9183_/CLK _9059_/D place2471/X VPWR VGND sg13g2_dfrbpq_1
XFILLER_76_459 VPWR VGND sg13g2_decap_8
Xhold3085 _8209_/A _9105_/Q VPWR VGND sg13g2_dlygate4sd3_1
Xhold3096 _5636_/B2 _8621_/Q VPWR VGND sg13g2_dlygate4sd3_1
XFILLER_48_139 VPWR VGND sg13g2_fill_1
X_9533__2847 _9533_/RESET_B VPWR VGND sg13g2_tiehi
XFILLER_71_120 VPWR VGND sg13g2_fill_1
XFILLER_13_776 VPWR VGND sg13g2_decap_8
XFILLER_40_562 VPWR VGND sg13g2_fill_1
XFILLER_60_40 VPWR VGND sg13g2_decap_8
XFILLER_8_224 VPWR VGND sg13g2_decap_8
XFILLER_8_279 VPWR VGND sg13g2_fill_2
XFILLER_114_807 VPWR VGND sg13g2_fill_2
XFILLER_5_35 VPWR VGND sg13g2_decap_8
XFILLER_79_220 VPWR VGND sg13g2_fill_1
XFILLER_79_275 VPWR VGND sg13g2_fill_2
XFILLER_39_117 VPWR VGND sg13g2_decap_8
XFILLER_39_139 VPWR VGND sg13g2_decap_4
XFILLER_35_312 VPWR VGND sg13g2_decap_8
XFILLER_63_643 VPWR VGND sg13g2_decap_8
X_9509__2871 _9509_/RESET_B VPWR VGND sg13g2_tiehi
XFILLER_90_484 VPWR VGND sg13g2_fill_2
XFILLER_90_473 VPWR VGND sg13g2_decap_8
X_6760_ _9519_/D _9519_/Q _9429_/Q _6783_/S VPWR VGND sg13g2_mux2_1
XFILLER_23_518 VPWR VGND sg13g2_fill_1
X_5711_ _5711_/X _5716_/A _9308_/Q _5716_/C VPWR VGND sg13g2_and3_1
XFILLER_16_581 VPWR VGND sg13g2_decap_8
X_6691_ _6692_/C _9463_/Q _7811_/C VPWR VGND sg13g2_nand2b_1
X_8430_ _8430_/Y _8430_/A _9219_/Q _8430_/C VPWR VGND sg13g2_nand3_1
X_5642_ _5643_/B _4457_/X _5629_/A _5642_/B1 VPWR VGND sg13g2_a21oi_1
X_5573_ _5573_/Y _5585_/A _5585_/B _8647_/Q _5585_/D VPWR VGND sg13g2_nand4_1
X_8361_ _8361_/Y _8383_/A _9181_/Q _8361_/C VPWR VGND sg13g2_nand3_1
X_4524_ _4525_/A _9471_/Q _8496_/A _8496_/B VPWR VGND sg13g2_o21ai_1
X_7312_ _7313_/D _9148_/Q _7385_/B VPWR VGND sg13g2_nor2_1
X_8292_ _9146_/D _8314_/A1 _7889_/Y _8291_/Y VPWR VGND sg13g2_o21ai_1
X_7243_ _8895_/D _7812_/S _7242_/Y _7240_/Y VPWR VGND sg13g2_a21oi_1
XFILLER_104_317 VPWR VGND sg13g2_fill_1
X_9583__2807 _9583_/RESET_B VPWR VGND sg13g2_tiehi
X_4455_ _4456_/C _9691_/Q _4455_/B VPWR VGND sg13g2_and2_1
X_7174_ _8876_/D _7173_/Y _8876_/Q _7185_/S VPWR VGND sg13g2_mux2_1
X_4386_ _5500_/C _9705_/Q _9695_/Q VPWR VGND sg13g2_or2_1
XFILLER_105_14 VPWR VGND sg13g2_fill_1
X_6125_ _6333_/C _6262_/A _9245_/Q _6262_/C VPWR VGND sg13g2_nand3_1
XFILLER_86_746 VPWR VGND sg13g2_decap_8
X_6056_ _6056_/Y _6053_/B _6275_/B _6021_/X VPWR VGND sg13g2_a21oi_1
X_5007_ _5007_/X _9405_/Q _4934_/B _5006_/Y VPWR VGND sg13g2_a21o_1
XFILLER_121_35 VPWR VGND sg13g2_decap_8
XFILLER_54_632 VPWR VGND sg13g2_decap_8
XFILLER_53_131 VPWR VGND sg13g2_decap_8
XFILLER_26_334 VPWR VGND sg13g2_fill_1
XFILLER_54_687 VPWR VGND sg13g2_fill_2
XFILLER_53_153 VPWR VGND sg13g2_decap_8
XFILLER_26_378 VPWR VGND sg13g2_decap_8
XFILLER_53_186 VPWR VGND sg13g2_fill_1
X_6958_ _7036_/C _8820_/D _6962_/B _6958_/C VPWR VGND sg13g2_and3_1
XFILLER_41_337 VPWR VGND sg13g2_fill_1
X_6889_ _6889_/X _8918_/Q _8950_/Q _6901_/S VPWR VGND sg13g2_mux2_1
X_5909_ _5909_/Y _5909_/A _5909_/B _5925_/C VPWR VGND sg13g2_nand3_1
X_9677_ _9677_/Q _9678_/CLK _9677_/D fanout965/X VPWR VGND sg13g2_dfrbpq_1
XFILLER_22_551 VPWR VGND sg13g2_decap_8
X_8628_ _8628_/Q _9678_/CLK _8628_/D fanout968/X VPWR VGND sg13g2_dfrbpq_1
XFILLER_14_66 VPWR VGND sg13g2_decap_8
XFILLER_22_584 VPWR VGND sg13g2_decap_8
XFILLER_108_601 VPWR VGND sg13g2_fill_1
X_8559_ _9272_/D _8559_/A VPWR VGND sg13g2_inv_1
XFILLER_108_623 VPWR VGND sg13g2_fill_1
XFILLER_5_216 VPWR VGND sg13g2_fill_2
XFILLER_30_32 VPWR VGND sg13g2_decap_4
Xclkbuf_leaf_21_clk_i _9253_/CLK clkload1/A VPWR VGND sg13g2_buf_16
Xplace2191 _5177_/A _5085_/D VPWR VGND sg13g2_buf_1
Xplace2180 _7820_/C _7723_/C VPWR VGND sg13g2_buf_1
XFILLER_123_659 VPWR VGND sg13g2_decap_8
XFILLER_107_199 VPWR VGND sg13g2_fill_2
X_9559__2831 _9559_/RESET_B VPWR VGND sg13g2_tiehi
XFILLER_76_201 VPWR VGND sg13g2_decap_8
XFILLER_92_705 VPWR VGND sg13g2_fill_1
XFILLER_39_85 VPWR VGND sg13g2_decap_8
XFILLER_39_96 VPWR VGND sg13g2_decap_8
XFILLER_17_301 VPWR VGND sg13g2_fill_2
XFILLER_29_172 VPWR VGND sg13g2_decap_4
XFILLER_45_632 VPWR VGND sg13g2_decap_8
XFILLER_60_657 VPWR VGND sg13g2_decap_8
XFILLER_60_668 VPWR VGND sg13g2_fill_2
XFILLER_13_562 VPWR VGND sg13g2_fill_2
XFILLER_40_381 VPWR VGND sg13g2_decap_8
XFILLER_9_577 VPWR VGND sg13g2_decap_8
XFILLER_95_543 VPWR VGND sg13g2_decap_8
XFILLER_68_735 VPWR VGND sg13g2_fill_1
XFILLER_83_705 VPWR VGND sg13g2_decap_4
XFILLER_67_245 VPWR VGND sg13g2_decap_8
XFILLER_67_278 VPWR VGND sg13g2_decap_4
XFILLER_48_481 VPWR VGND sg13g2_decap_4
X_7930_ _7930_/Y _7956_/A _8977_/Q _8391_/C VPWR VGND sg13g2_nand3_1
X_7861_ _7861_/Y _9258_/Q _8513_/B _7861_/B1 VPWR VGND sg13g2_a21oi_1
XFILLER_48_492 VPWR VGND sg13g2_decap_8
XFILLER_35_120 VPWR VGND sg13g2_decap_8
XFILLER_35_131 VPWR VGND sg13g2_fill_2
XFILLER_36_643 VPWR VGND sg13g2_fill_2
X_9600_ _9600_/Q _9603_/CLK _9600_/D _9600_/RESET_B VPWR VGND sg13g2_dfrbpq_1
X_6812_ _9560_/D _9593_/Q _9560_/Q _6813_/S VPWR VGND sg13g2_mux2_1
X_7792_ _7792_/Y _7788_/Y _7791_/X _5377_/X VPWR VGND sg13g2_a21oi_1
XFILLER_63_495 VPWR VGND sg13g2_decap_8
XFILLER_51_624 VPWR VGND sg13g2_decap_8
X_9531_ _9531_/Q _9582_/CLK _9531_/D _9531_/RESET_B VPWR VGND sg13g2_dfrbpq_1
X_6743_ _6743_/Y _9210_/Q _9648_/Q _6743_/C _6743_/D VPWR VGND sg13g2_nor4_1
X_9462_ _9462_/Q _9675_/CLK _9462_/D place2446/X VPWR VGND sg13g2_dfrbpq_1
X_6674_ _9453_/D _6569_/Y _6673_/Y _6671_/Y VPWR VGND sg13g2_o21ai_1
XFILLER_50_178 VPWR VGND sg13g2_fill_2
X_8413_ _8430_/A _8498_/D _8413_/B VPWR VGND sg13g2_nand2_1
X_5625_ _5660_/B _6915_/A _5625_/B _5629_/C _5629_/B VPWR VGND sg13g2_nand4_1
X_9393_ _9393_/Q _9406_/CLK _9393_/D place2390/X VPWR VGND sg13g2_dfrbpq_1
X_5556_ _5556_/Y _8641_/Q _5592_/A2 _5586_/B1 _8640_/Q VPWR VGND sg13g2_a22oi_1
X_8344_ _9172_/D _8344_/A1 _8095_/Y _8343_/Y VPWR VGND sg13g2_o21ai_1
X_4507_ _8515_/B _9503_/Q _9504_/Q VPWR VGND sg13g2_nor2b_1
X_5487_ _5493_/C _6948_/B _5486_/Y _5479_/Y VPWR VGND sg13g2_o21ai_1
X_8275_ _8275_/Y _9138_/Q _8287_/B VPWR VGND sg13g2_nand2_1
XFILLER_105_648 VPWR VGND sg13g2_decap_8
X_7226_ _7226_/Y _7238_/A1 _7224_/Y _7225_/Y VPWR VGND sg13g2_a21oi_1
X_4438_ _4440_/A _7175_/B _7172_/A _7182_/B _7179_/A VPWR VGND sg13g2_nor4_1
X_4369_ _4481_/C _9662_/Q _9660_/Q _9657_/Q VPWR VGND sg13g2_nor3_1
XFILLER_113_692 VPWR VGND sg13g2_fill_2
X_7157_ _8871_/D _6975_/X _7155_/Y _7156_/Y VPWR VGND sg13g2_o21ai_1
X_6108_ _6108_/X _8963_/Q _9025_/Q _9087_/Q _9149_/Q _6377_/S0 _6363_/S1 VPWR VGND
+ sg13g2_mux4_1
X_7088_ _7088_/Y _5360_/C _7130_/A2 _7087_/Y VPWR VGND sg13g2_o21ai_1
XFILLER_58_278 VPWR VGND sg13g2_fill_2
X_6039_ _6039_/X _6041_/B _6365_/C _6365_/B _6049_/A VPWR VGND sg13g2_and4_1
XFILLER_26_120 VPWR VGND sg13g2_fill_1
XFILLER_27_643 VPWR VGND sg13g2_fill_2
XFILLER_42_657 VPWR VGND sg13g2_decap_8
XFILLER_10_521 VPWR VGND sg13g2_decap_8
XFILLER_22_392 VPWR VGND sg13g2_decap_8
Xclkbuf_leaf_4_jtag_tck_i_regs _9511_/CLK clkbuf_leaf_6_jtag_tck_i_regs/A VPWR VGND
+ sg13g2_buf_16
X_9483__2897 _9483_/RESET_B VPWR VGND sg13g2_tiehi
XFILLER_6_525 VPWR VGND sg13g2_fill_1
XFILLER_6_514 VPWR VGND sg13g2_fill_1
XFILLER_9_0 VPWR VGND sg13g2_decap_8
XFILLER_96_307 VPWR VGND sg13g2_fill_1
XFILLER_49_223 VPWR VGND sg13g2_decap_4
XFILLER_2_14 VPWR VGND sg13g2_decap_8
XFILLER_66_72 VPWR VGND sg13g2_decap_8
XFILLER_49_289 VPWR VGND sg13g2_decap_4
XFILLER_49_278 VPWR VGND sg13g2_fill_1
XFILLER_92_557 VPWR VGND sg13g2_decap_8
XFILLER_64_237 VPWR VGND sg13g2_decap_8
XFILLER_17_120 VPWR VGND sg13g2_fill_1
XFILLER_18_621 VPWR VGND sg13g2_decap_8
XFILLER_18_687 VPWR VGND sg13g2_decap_8
XFILLER_18_676 VPWR VGND sg13g2_decap_4
XFILLER_18_698 VPWR VGND sg13g2_fill_2
XFILLER_9_374 VPWR VGND sg13g2_fill_2
X_5410_ _5410_/Y _5410_/A _5410_/B _8747_/Q VPWR VGND sg13g2_nand3_1
X_6390_ _6390_/Y _6389_/X _6390_/A2 _8874_/Q _6958_/C VPWR VGND sg13g2_a22oi_1
X_5341_ _8783_/D _5341_/A1 _5375_/C _5338_/Y _5340_/Y VPWR VGND sg13g2_a22oi_1
XFILLER_88_808 VPWR VGND sg13g2_fill_1
X_8060_ _8060_/Y _9036_/Q _8094_/B VPWR VGND sg13g2_nand2_1
XFILLER_99_145 VPWR VGND sg13g2_fill_2
X_7011_ _7011_/Y _8003_/A _8826_/Q _8089_/A VPWR VGND sg13g2_nand3_1
X_5272_ _5273_/B _5272_/A _5286_/B _9878_/A _9879_/A VPWR VGND sg13g2_nand4_1
XFILLER_114_489 VPWR VGND sg13g2_fill_1
Xhold2939 _4487_/A2 _9643_/Q VPWR VGND sg13g2_dlygate4sd3_1
Xhold2928 _8725_/D _8724_/Q VPWR VGND sg13g2_dlygate4sd3_1
XFILLER_68_598 VPWR VGND sg13g2_decap_8
XFILLER_56_727 VPWR VGND sg13g2_fill_1
XFILLER_55_215 VPWR VGND sg13g2_decap_4
X_8962_ _8962_/Q _9183_/CLK _8962_/D place2469/X VPWR VGND sg13g2_dfrbpq_1
XFILLER_55_248 VPWR VGND sg13g2_decap_8
X_7913_ _7913_/Y _7917_/A _8970_/Q _8375_/C VPWR VGND sg13g2_nand3_1
X_8893_ _8893_/Q _9253_/CLK _8893_/D place2463/X VPWR VGND sg13g2_dfrbpq_1
X_7844_ _7845_/B _8814_/Q _7824_/B _7694_/B _9888_/A VPWR VGND sg13g2_a22oi_1
XFILLER_70_229 VPWR VGND sg13g2_fill_1
XFILLER_63_281 VPWR VGND sg13g2_fill_1
XFILLER_51_410 VPWR VGND sg13g2_decap_8
X_7775_ _7775_/Y _7775_/A _7775_/B _7775_/C _7775_/D VPWR VGND sg13g2_nor4_1
XFILLER_51_465 VPWR VGND sg13g2_fill_1
XFILLER_23_134 VPWR VGND sg13g2_fill_1
X_6726_ _9494_/D _9535_/Q _9494_/Q _6726_/S VPWR VGND sg13g2_mux2_1
X_9514_ _9514_/Q _9587_/CLK _9514_/D _9514_/RESET_B VPWR VGND sg13g2_dfrbpq_1
X_4987_ _4987_/Y _4994_/A _9371_/Q VPWR VGND sg13g2_nor2b_1
XFILLER_11_307 VPWR VGND sg13g2_decap_8
X_9445_ _9445_/Q _9582_/CLK _9445_/D fanout983/X VPWR VGND sg13g2_dfrbpq_1
X_6657_ _6657_/Y _6657_/A _6660_/B VPWR VGND sg13g2_nand2_1
X_6588_ _6588_/X _6672_/A _9562_/Q _6588_/C VPWR VGND sg13g2_or3_1
X_9376_ _9376_/Q _9692_/CLK _9376_/D place2502/X VPWR VGND sg13g2_dfrbpq_1
X_5608_ _8657_/D _5607_/Y _5606_/Y _5623_/B1 VPWR VGND sg13g2_a21oi_1
X_8327_ _8327_/Y _8327_/A _8345_/B VPWR VGND sg13g2_nand2_1
X_5539_ _8634_/D _5538_/Y _5537_/Y _6546_/D VPWR VGND sg13g2_a21oi_1
XFILLER_3_506 VPWR VGND sg13g2_decap_4
XFILLER_105_423 VPWR VGND sg13g2_fill_2
XFILLER_87_27 VPWR VGND sg13g2_fill_2
X_8258_ _9129_/D _8563_/D _8061_/Y _8257_/Y VPWR VGND sg13g2_o21ai_1
XFILLER_2_7 VPWR VGND sg13g2_decap_8
XFILLER_120_426 VPWR VGND sg13g2_decap_8
X_9468__2912 _9468_/RESET_B VPWR VGND sg13g2_tiehi
X_7209_ _8886_/D _7208_/Y _8886_/Q _7213_/S VPWR VGND sg13g2_mux2_1
X_8189_ _8189_/Y _8189_/A _8191_/B VPWR VGND sg13g2_nand2_1
XFILLER_100_161 VPWR VGND sg13g2_decap_8
XFILLER_100_172 VPWR VGND sg13g2_fill_2
XFILLER_46_259 VPWR VGND sg13g2_decap_4
XFILLER_15_635 VPWR VGND sg13g2_decap_8
XFILLER_15_679 VPWR VGND sg13g2_decap_8
XFILLER_52_74 VPWR VGND sg13g2_decap_8
XFILLER_97_616 VPWR VGND sg13g2_fill_2
XFILLER_97_605 VPWR VGND sg13g2_decap_8
XFILLER_123_286 VPWR VGND sg13g2_fill_2
XFILLER_97_638 VPWR VGND sg13g2_decap_8
XFILLER_35_7 VPWR VGND sg13g2_decap_4
XFILLER_96_148 VPWR VGND sg13g2_decap_4
XFILLER_38_727 VPWR VGND sg13g2_decap_8
XFILLER_38_749 VPWR VGND sg13g2_decap_4
XFILLER_92_365 VPWR VGND sg13g2_fill_2
XFILLER_80_516 VPWR VGND sg13g2_decap_8
XFILLER_80_505 VPWR VGND sg13g2_fill_1
XFILLER_18_440 VPWR VGND sg13g2_fill_2
X_5890_ _5890_/Y _5890_/A _5890_/B _5952_/B _5890_/D VPWR VGND sg13g2_nand4_1
XFILLER_18_484 VPWR VGND sg13g2_decap_8
X_4910_ _4910_/Y _5017_/A1 _4908_/Y _4909_/Y VPWR VGND sg13g2_o21ai_1
X_4841_ _4841_/Y _8818_/Q _9352_/Q VPWR VGND sg13g2_nor2b_1
XFILLER_60_262 VPWR VGND sg13g2_fill_1
XFILLER_33_487 VPWR VGND sg13g2_decap_8
X_7560_ _7574_/A _7560_/A _7560_/B _7560_/C VPWR VGND sg13g2_and3_1
X_4772_ _4959_/A _4772_/A _4880_/B VPWR VGND sg13g2_nor2b_1
X_7491_ _7494_/B _9157_/Q _7491_/B VPWR VGND sg13g2_nor2_1
X_6511_ _6511_/Y _8894_/Q _6511_/A2 _6510_/Y _6410_/Y _6508_/Y VPWR VGND sg13g2_a221oi_1
X_6442_ _9396_/D _6441_/Y _6491_/A2 _6437_/Y VPWR VGND sg13g2_a21oi_1
X_9230_ _9230_/Q _9242_/CLK _9230_/D place2495/X VPWR VGND sg13g2_dfrbpq_1
X_9161_ _9161_/Q _9501_/CLK _9161_/D place2470/X VPWR VGND sg13g2_dfrbpq_1
X_8112_ _9056_/D _8120_/A1 _7897_/Y _8111_/Y VPWR VGND sg13g2_o21ai_1
X_6373_ _6373_/Y _6373_/A1 _6373_/A2 _9382_/Q VPWR VGND sg13g2_a21oi_1
X_5324_ _5373_/C _8061_/A _9500_/Q VPWR VGND sg13g2_nand2_1
X_9092_ _9092_/Q _9188_/CLK _9092_/D place2474/X VPWR VGND sg13g2_dfrbpq_1
XFILLER_114_264 VPWR VGND sg13g2_decap_4
XFILLER_88_627 VPWR VGND sg13g2_fill_2
X_5255_ _5256_/B _5334_/A _5255_/B _9876_/A VPWR VGND sg13g2_nand3_1
X_8043_ _9029_/D _8100_/A1 _8042_/Y _8041_/Y VPWR VGND sg13g2_o21ai_1
X_5186_ _5192_/D _5187_/C _5185_/Y _5156_/Y _5159_/C VPWR VGND sg13g2_a22oi_1
XFILLER_68_373 VPWR VGND sg13g2_decap_4
XFILLER_29_705 VPWR VGND sg13g2_fill_2
XFILLER_110_470 VPWR VGND sg13g2_decap_4
XFILLER_95_192 VPWR VGND sg13g2_decap_4
XFILLER_95_170 VPWR VGND sg13g2_decap_8
XFILLER_56_546 VPWR VGND sg13g2_decap_8
X_8945_ _8945_/Q _9611_/CLK _8945_/D place2412/X VPWR VGND sg13g2_dfrbpq_1
XFILLER_83_365 VPWR VGND sg13g2_fill_2
XFILLER_83_354 VPWR VGND sg13g2_fill_2
XFILLER_83_343 VPWR VGND sg13g2_decap_8
X_8876_ _8876_/Q _9692_/CLK _8876_/D place2492/X VPWR VGND sg13g2_dfrbpq_1
XFILLER_36_270 VPWR VGND sg13g2_fill_1
XFILLER_43_229 VPWR VGND sg13g2_decap_4
X_7827_ _7827_/Y _7827_/A _7827_/B _7827_/C _7827_/D VPWR VGND sg13g2_nand4_1
XFILLER_12_605 VPWR VGND sg13g2_decap_4
Xinput2602 _6004_/A master_rdata_i[31] VPWR VGND sg13g2_buf_1
X_7758_ _7772_/A _9300_/Q _7843_/A2 _7843_/B1 _9332_/Q _7757_/Y VPWR VGND sg13g2_a221oi_1
Xinput2613 _6046_/A slave_addr_i[1] VPWR VGND sg13g2_buf_1
XFILLER_8_609 VPWR VGND sg13g2_fill_1
Xinput2624 _7165_/A slave_wdata_i[10] VPWR VGND sg13g2_buf_1
X_7689_ _7692_/A _7690_/A _7741_/B _9105_/Q VPWR VGND sg13g2_nor3_1
X_6709_ _9477_/D _9518_/Q _9477_/Q _6710_/S VPWR VGND sg13g2_mux2_1
XFILLER_11_159 VPWR VGND sg13g2_decap_8
XFILLER_22_11 VPWR VGND sg13g2_fill_2
Xinput2635 _7201_/A slave_wdata_i[20] VPWR VGND sg13g2_buf_1
Xinput2646 _7236_/B slave_wdata_i[30] VPWR VGND sg13g2_buf_1
X_9428_ _9428_/Q _9678_/CLK _9428_/D fanout978/X VPWR VGND sg13g2_dfrbpq_1
XFILLER_20_682 VPWR VGND sg13g2_decap_8
XFILLER_98_15 VPWR VGND sg13g2_fill_1
XFILLER_106_721 VPWR VGND sg13g2_fill_1
XFILLER_105_220 VPWR VGND sg13g2_decap_8
X_9359_ _9359_/Q _9406_/CLK _9359_/D place2454/X VPWR VGND sg13g2_dfrbpq_1
XFILLER_105_231 VPWR VGND sg13g2_fill_2
XFILLER_105_275 VPWR VGND sg13g2_fill_2
XFILLER_121_746 VPWR VGND sg13g2_decap_8
XFILLER_120_234 VPWR VGND sg13g2_decap_8
XFILLER_120_223 VPWR VGND sg13g2_decap_8
XFILLER_19_204 VPWR VGND sg13g2_decap_8
XFILLER_86_192 VPWR VGND sg13g2_decap_8
XFILLER_90_803 VPWR VGND sg13g2_fill_2
XFILLER_62_505 VPWR VGND sg13g2_fill_1
XFILLER_19_259 VPWR VGND sg13g2_fill_2
XFILLER_47_85 VPWR VGND sg13g2_decap_8
XFILLER_62_549 VPWR VGND sg13g2_fill_1
XFILLER_70_582 VPWR VGND sg13g2_fill_2
XFILLER_70_571 VPWR VGND sg13g2_decap_8
XFILLER_11_660 VPWR VGND sg13g2_fill_2
XFILLER_8_35 VPWR VGND sg13g2_decap_8
XFILLER_30_457 VPWR VGND sg13g2_decap_8
XFILLER_10_170 VPWR VGND sg13g2_decap_4
Xplace2009 _5623_/B1 _6544_/A VPWR VGND sg13g2_buf_1
X_5040_ _5040_/Y _5057_/A _5098_/A _6534_/D VPWR VGND sg13g2_nor3_1
XFILLER_88_92 VPWR VGND sg13g2_fill_1
X_6991_ _6992_/D _8827_/Q _7719_/B _6989_/Y VPWR VGND sg13g2_o21ai_1
XFILLER_38_557 VPWR VGND sg13g2_decap_4
X_5942_ _5942_/Y _9484_/Q _5980_/A2 _5941_/Y VPWR VGND sg13g2_a21oi_1
XFILLER_92_173 VPWR VGND sg13g2_fill_1
X_8730_ _8730_/Q _9153_/CLK _8730_/D place2440/X VPWR VGND sg13g2_dfrbpq_1
XFILLER_53_538 VPWR VGND sg13g2_decap_8
XFILLER_18_292 VPWR VGND sg13g2_decap_8
XFILLER_34_741 VPWR VGND sg13g2_fill_1
X_5873_ _5873_/X _5998_/A _5937_/B2 _5889_/S VPWR VGND sg13g2_mux2_1
XFILLER_61_571 VPWR VGND sg13g2_decap_8
X_8661_ _8661_/Q _9686_/CLK _8661_/D fanout957/X VPWR VGND sg13g2_dfrbpq_1
XFILLER_34_763 VPWR VGND sg13g2_decap_8
XFILLER_34_774 VPWR VGND sg13g2_fill_1
XFILLER_34_796 VPWR VGND sg13g2_fill_1
X_7612_ _7615_/B _7606_/Y _7611_/Y _8068_/D VPWR VGND sg13g2_o21ai_1
X_4824_ _4824_/Y _4842_/A _4776_/B _6010_/A0 VPWR VGND sg13g2_o21ai_1
X_8592_ _8592_/Q _9708_/CLK _8592_/D fanout948/X VPWR VGND sg13g2_dfrbpq_1
X_7543_ _7543_/Y _7785_/A _7543_/B _7543_/C _7543_/D VPWR VGND sg13g2_nor4_1
X_4755_ _4755_/Y _8817_/Q _9345_/Q _4754_/Y VPWR VGND sg13g2_o21ai_1
XFILLER_21_479 VPWR VGND sg13g2_decap_4
X_4686_ _4687_/B _4480_/B _8743_/Q _9658_/Q VPWR VGND sg13g2_a21oi_1
X_9213_ _9213_/Q _9254_/CLK _9213_/D place2402/X VPWR VGND sg13g2_dfrbpq_1
X_7474_ _7476_/A _9317_/Q _7826_/A2 _7533_/B1 _8875_/Q _7455_/Y VPWR VGND sg13g2_a221oi_1
Xplace2532 _6349_/S1 _6158_/A VPWR VGND sg13g2_buf_1
Xplace2521 _6302_/S0 _6061_/A VPWR VGND sg13g2_buf_1
Xplace2510 _6510_/B _6408_/B VPWR VGND sg13g2_buf_1
X_6425_ _6425_/X _9007_/Q _9069_/Q _9131_/Q _9193_/Q _6480_/S0 _6480_/S1 VPWR VGND
+ sg13g2_mux4_1
Xplace1820 _8159_/B _8157_/B VPWR VGND sg13g2_buf_1
XFILLER_108_36 VPWR VGND sg13g2_fill_1
X_6356_ _9379_/D _6056_/Y _6354_/Y _6355_/Y VPWR VGND sg13g2_a21oi_1
Xplace1831 _7985_/A _8017_/A VPWR VGND sg13g2_buf_1
Xplace1853 _6319_/C1 _6253_/S VPWR VGND sg13g2_buf_1
Xplace1842 _7904_/A _7924_/A VPWR VGND sg13g2_buf_1
X_9144_ _9144_/Q _9501_/CLK _9144_/D place2468/X VPWR VGND sg13g2_dfrbpq_1
XFILLER_115_562 VPWR VGND sg13g2_fill_2
Xplace1875 _7881_/S _7883_/S VPWR VGND sg13g2_buf_1
Xhold3201 _6688_/B1 _9461_/Q VPWR VGND sg13g2_dlygate4sd3_1
X_5307_ _5308_/B _5316_/A _5313_/C _5314_/D _9884_/A VPWR VGND sg13g2_nand4_1
X_9075_ _9075_/Q _9199_/CLK _9075_/D place2424/X VPWR VGND sg13g2_dfrbpq_1
XFILLER_68_18 VPWR VGND sg13g2_fill_1
Xplace1897 _6491_/A2 _6432_/S VPWR VGND sg13g2_buf_1
XFILLER_0_317 VPWR VGND sg13g2_fill_2
Xhold3212 _5681_/B2 _8594_/Q VPWR VGND sg13g2_dlygate4sd3_1
Xplace1886 _7105_/C _6974_/A VPWR VGND sg13g2_buf_1
Xplace1864 _8444_/A _8492_/A VPWR VGND sg13g2_buf_1
Xhold3223 _6448_/B1 _9397_/Q VPWR VGND sg13g2_dlygate4sd3_1
XFILLER_103_768 VPWR VGND sg13g2_fill_1
Xhold3234 _4474_/A _9666_/Q VPWR VGND sg13g2_dlygate4sd3_1
Xhold3245 _4366_/B _9668_/Q VPWR VGND sg13g2_dlygate4sd3_1
X_8026_ _8026_/Y _8026_/A _8052_/B VPWR VGND sg13g2_nand2_1
X_6287_ _6287_/Y _6328_/C _6287_/B _6328_/A VPWR VGND sg13g2_nand3_1
X_5238_ _5280_/B _5238_/A _9871_/A _9872_/A _9873_/A VPWR VGND sg13g2_and4_1
X_5169_ _5169_/Y _5169_/A _5169_/B VPWR VGND sg13g2_xnor2_1
XFILLER_84_674 VPWR VGND sg13g2_decap_8
XFILLER_68_192 VPWR VGND sg13g2_decap_8
XFILLER_29_557 VPWR VGND sg13g2_decap_4
X_8928_ _8928_/Q _9603_/CLK _8928_/D place2431/X VPWR VGND sg13g2_dfrbpq_1
XFILLER_71_346 VPWR VGND sg13g2_decap_4
XFILLER_44_549 VPWR VGND sg13g2_decap_8
XFILLER_52_560 VPWR VGND sg13g2_fill_1
X_8859_ _8859_/Q _9407_/CLK _8859_/D place2459/X VPWR VGND sg13g2_dfrbpq_1
XFILLER_25_774 VPWR VGND sg13g2_fill_1
XFILLER_12_446 VPWR VGND sg13g2_decap_8
XFILLER_12_413 VPWR VGND sg13g2_decap_8
XFILLER_25_796 VPWR VGND sg13g2_fill_2
XFILLER_40_799 VPWR VGND sg13g2_fill_2
XFILLER_109_0 VPWR VGND sg13g2_decap_8
XFILLER_4_656 VPWR VGND sg13g2_decap_8
XFILLER_121_521 VPWR VGND sg13g2_fill_2
XFILLER_79_479 VPWR VGND sg13g2_fill_1
XFILLER_67_619 VPWR VGND sg13g2_decap_4
XFILLER_58_51 VPWR VGND sg13g2_decap_4
XFILLER_48_800 VPWR VGND sg13g2_fill_1
XFILLER_87_490 VPWR VGND sg13g2_fill_2
XFILLER_90_699 VPWR VGND sg13g2_decap_8
XFILLER_15_240 VPWR VGND sg13g2_fill_2
XFILLER_30_232 VPWR VGND sg13g2_fill_2
XFILLER_30_276 VPWR VGND sg13g2_fill_1
XFILLER_31_799 VPWR VGND sg13g2_fill_2
XFILLER_116_304 VPWR VGND sg13g2_decap_8
X_4540_ _5400_/A _7032_/C _7032_/D _7831_/C VPWR VGND sg13g2_a21oi_1
X_4471_ _4708_/A _8728_/Q _9667_/Q VPWR VGND sg13g2_nor2b_1
XFILLER_7_494 VPWR VGND sg13g2_decap_8
XFILLER_98_700 VPWR VGND sg13g2_fill_1
X_6210_ _9360_/D _6208_/Y _6206_/Y _6209_/Y VPWR VGND sg13g2_a21oi_1
X_7190_ _8880_/D _7189_/Y _8880_/Q _7213_/S VPWR VGND sg13g2_mux2_1
XFILLER_112_510 VPWR VGND sg13g2_decap_8
XFILLER_98_722 VPWR VGND sg13g2_decap_8
X_6141_ _9351_/D _6056_/Y _6138_/Y _6140_/Y VPWR VGND sg13g2_a21oi_1
X_9496__2884 _9496_/RESET_B VPWR VGND sg13g2_tiehi
XFILLER_112_521 VPWR VGND sg13g2_fill_1
XFILLER_112_565 VPWR VGND sg13g2_decap_8
X_6072_ _6073_/A _8834_/Q _6375_/A2 _6042_/Y _6070_/X _6071_/Y VPWR VGND sg13g2_a221oi_1
XFILLER_24_0 VPWR VGND sg13g2_decap_4
X_5023_ _5178_/D _5187_/A _5160_/B VPWR VGND sg13g2_nor2_1
XFILLER_85_427 VPWR VGND sg13g2_fill_1
XFILLER_78_490 VPWR VGND sg13g2_decap_8
XFILLER_81_666 VPWR VGND sg13g2_decap_8
XFILLER_81_644 VPWR VGND sg13g2_fill_1
X_6974_ _6974_/Y _6974_/A _6975_/B VPWR VGND sg13g2_nor2_1
X_5925_ _5925_/Y _5925_/A _5925_/B _5925_/C VPWR VGND sg13g2_nand3_1
X_8713_ _8713_/Q _9662_/CLK _8713_/D place2445/X VPWR VGND sg13g2_dfrbpq_1
X_9693_ _9693_/Q _9708_/CLK _9693_/D fanout955/X VPWR VGND sg13g2_dfrbpq_1
X_8644_ _8644_/Q _9449_/CLK _8644_/D fanout970/X VPWR VGND sg13g2_dfrbpq_1
X_5856_ _5856_/Y _5837_/A2 _9474_/Q VPWR VGND sg13g2_nand2b_1
XFILLER_22_755 VPWR VGND sg13g2_decap_4
X_4807_ _4807_/X _4816_/A _4807_/B _4807_/C VPWR VGND sg13g2_or3_1
X_8575_ _8575_/Y _8577_/A _8577_/B _8575_/C VPWR VGND sg13g2_nand3_1
X_5787_ _5787_/Y _7006_/C _8563_/C _5787_/C _7024_/D VPWR VGND sg13g2_nor4_1
XFILLER_22_799 VPWR VGND sg13g2_fill_2
XFILLER_119_35 VPWR VGND sg13g2_decap_8
X_4738_ _9692_/D _4432_/B _4737_/Y _4736_/Y VPWR VGND sg13g2_a21o_1
X_7526_ _7530_/B _7820_/A _9004_/Q _7820_/C VPWR VGND sg13g2_nor3_1
XFILLER_119_186 VPWR VGND sg13g2_decap_8
XFILLER_119_164 VPWR VGND sg13g2_decap_8
XFILLER_119_68 VPWR VGND sg13g2_decap_8
Xplace2340 _5930_/A1 _5924_/D VPWR VGND sg13g2_buf_1
XFILLER_107_315 VPWR VGND sg13g2_decap_4
X_4669_ _4670_/A _4669_/A1 _6569_/B _4666_/A _9210_/Q VPWR VGND sg13g2_a22oi_1
X_7457_ _7458_/D _8794_/Q _7301_/B _7579_/A2 _8843_/Q VPWR VGND sg13g2_a22oi_1
Xplace2351 _8399_/C _8061_/A VPWR VGND sg13g2_buf_1
Xplace2362 _7236_/C _8496_/B VPWR VGND sg13g2_buf_1
X_6408_ _6408_/Y _6407_/Y _6408_/B VPWR VGND sg13g2_nand2b_1
Xplace2373 _8409_/C _8444_/C VPWR VGND sg13g2_buf_1
Xplace2395 place2395/X place2399/X VPWR VGND sg13g2_buf_1
Xdelaybuf_4_clk_jtg delaybuf_4_clk_jtg/X delaybuf_4_clk_jtg/A VPWR VGND sg13g2_buf_8
X_7388_ _7389_/D _9059_/Q _7381_/B _7386_/X VPWR VGND sg13g2_o21ai_1
Xplace2384 _6404_/B1 _6332_/C VPWR VGND sg13g2_buf_1
X_9127_ _9127_/Q clkload8/A _9127_/D place2475/X VPWR VGND sg13g2_dfrbpq_1
XFILLER_88_232 VPWR VGND sg13g2_fill_2
XFILLER_88_221 VPWR VGND sg13g2_decap_8
Xhold3031 _8097_/A _9049_/Q VPWR VGND sg13g2_dlygate4sd3_1
Xhold3020 _8107_/A _9054_/Q VPWR VGND sg13g2_dlygate4sd3_1
X_6339_ _6342_/A _6042_/C _6337_/X _6338_/Y VPWR VGND sg13g2_o21ai_1
Xhold3042 _8181_/A _9091_/Q VPWR VGND sg13g2_dlygate4sd3_1
Xhold3075 _6597_/A _9431_/Q VPWR VGND sg13g2_dlygate4sd3_1
XFILLER_88_265 VPWR VGND sg13g2_decap_8
X_9058_ _9058_/Q _9183_/CLK _9058_/D place2471/X VPWR VGND sg13g2_dfrbpq_1
Xhold3064 _5699_/B2 _8603_/Q VPWR VGND sg13g2_dlygate4sd3_1
Xhold3053 hold3053/X _8734_/Q VPWR VGND sg13g2_dlygate4sd3_1
Xhold3097 _7479_/A _8908_/Q VPWR VGND sg13g2_dlygate4sd3_1
X_8009_ _8009_/Y _8009_/A _9015_/Q _8401_/C VPWR VGND sg13g2_nand3_1
Xhold3086 _8311_/A _9156_/Q VPWR VGND sg13g2_dlygate4sd3_1
XFILLER_29_310 VPWR VGND sg13g2_decap_8
XFILLER_29_321 VPWR VGND sg13g2_fill_2
XFILLER_57_663 VPWR VGND sg13g2_fill_1
XFILLER_56_162 VPWR VGND sg13g2_fill_2
XFILLER_28_87 VPWR VGND sg13g2_decap_4
XFILLER_29_376 VPWR VGND sg13g2_fill_1
XFILLER_44_335 VPWR VGND sg13g2_decap_4
XFILLER_71_165 VPWR VGND sg13g2_decap_8
XFILLER_13_711 VPWR VGND sg13g2_decap_8
XFILLER_32_519 VPWR VGND sg13g2_fill_2
XFILLER_25_571 VPWR VGND sg13g2_fill_2
XFILLER_40_530 VPWR VGND sg13g2_decap_8
XFILLER_13_766 VPWR VGND sg13g2_decap_4
XFILLER_40_541 VPWR VGND sg13g2_fill_2
XFILLER_44_97 VPWR VGND sg13g2_decap_4
XFILLER_100_81 VPWR VGND sg13g2_decap_8
XFILLER_5_14 VPWR VGND sg13g2_decap_8
XFILLER_4_442 VPWR VGND sg13g2_decap_4
XFILLER_79_210 VPWR VGND sg13g2_fill_2
XFILLER_67_427 VPWR VGND sg13g2_decap_4
XFILLER_85_82 VPWR VGND sg13g2_decap_8
XFILLER_85_93 VPWR VGND sg13g2_fill_1
XFILLER_48_674 VPWR VGND sg13g2_fill_2
XFILLER_62_121 VPWR VGND sg13g2_fill_2
XFILLER_35_335 VPWR VGND sg13g2_fill_2
XFILLER_62_165 VPWR VGND sg13g2_decap_8
XFILLER_35_379 VPWR VGND sg13g2_decap_8
X_5710_ _5710_/X _5716_/A _9307_/Q _5716_/C VPWR VGND sg13g2_and3_1
X_6690_ _9462_/D _9462_/Q _9456_/Q _6690_/S VPWR VGND sg13g2_mux2_1
X_5641_ _5643_/A _8614_/Q _5660_/B VPWR VGND sg13g2_nor2_1
X_5572_ _8645_/D _5571_/Y _5570_/Y _5581_/B1 VPWR VGND sg13g2_a21oi_1
X_8360_ _9180_/D _5348_/C _8383_/A _8359_/Y VPWR VGND sg13g2_o21ai_1
X_4523_ _8745_/D _9471_/Q _4523_/B _6523_/A VPWR VGND sg13g2_nand3b_1
X_7311_ _7313_/B _7386_/A _9117_/Q _7387_/C VPWR VGND sg13g2_nor3_1
X_8291_ _8291_/Y _9146_/Q _8299_/B VPWR VGND sg13g2_nand2_1
X_7242_ _7242_/Y _4541_/Y _5376_/Y _7241_/X _7028_/B _5386_/Y VPWR VGND sg13g2_a221oi_1
Xclkbuf_leaf_2_clk_i _9198_/CLK clkbuf_leaf_9_clk_i/A VPWR VGND sg13g2_buf_16
XFILLER_116_189 VPWR VGND sg13g2_fill_2
XFILLER_116_178 VPWR VGND sg13g2_decap_8
X_4454_ _4455_/B _6018_/A _6015_/B _4518_/B _5392_/C VPWR VGND sg13g2_and4_1
X_4385_ _4590_/B _5628_/B _4591_/B VPWR VGND sg13g2_nor2_1
X_7173_ _7173_/Y _5356_/C _6978_/Y _7172_/Y VPWR VGND sg13g2_o21ai_1
XFILLER_86_714 VPWR VGND sg13g2_decap_4
X_6124_ _6124_/X _6262_/A _6262_/B _6262_/C VPWR VGND sg13g2_and3_1
XFILLER_112_384 VPWR VGND sg13g2_decap_4
XFILLER_98_585 VPWR VGND sg13g2_fill_2
XFILLER_58_438 VPWR VGND sg13g2_decap_4
X_6055_ _6253_/S _6055_/A _6055_/B VPWR VGND sg13g2_nand2_1
XFILLER_100_568 VPWR VGND sg13g2_fill_2
XFILLER_85_257 VPWR VGND sg13g2_fill_1
XFILLER_73_408 VPWR VGND sg13g2_decap_8
X_5006_ _5006_/Y _5006_/A1 _5005_/Y _4974_/C VPWR VGND sg13g2_o21ai_1
XFILLER_39_652 VPWR VGND sg13g2_fill_2
XFILLER_26_313 VPWR VGND sg13g2_fill_1
XFILLER_38_151 VPWR VGND sg13g2_fill_2
XFILLER_38_162 VPWR VGND sg13g2_fill_2
XFILLER_39_674 VPWR VGND sg13g2_decap_4
XFILLER_121_14 VPWR VGND sg13g2_decap_8
XFILLER_66_493 VPWR VGND sg13g2_fill_1
XFILLER_53_121 VPWR VGND sg13g2_fill_2
XFILLER_81_463 VPWR VGND sg13g2_fill_2
XFILLER_14_519 VPWR VGND sg13g2_decap_4
X_6957_ _7132_/D _8820_/D _6962_/B _6962_/D VPWR VGND sg13g2_nand3_1
X_5908_ _5909_/B _5954_/A _5932_/B _5986_/A _5924_/D VPWR VGND sg13g2_nand4_1
X_6888_ _9610_/D _6887_/X _9610_/Q _6902_/S VPWR VGND sg13g2_mux2_1
X_9676_ _9676_/Q _9678_/CLK _9676_/D fanout965/X VPWR VGND sg13g2_dfrbpq_1
X_5839_ _9306_/D _9306_/Q _5920_/B _5838_/Y VPWR VGND sg13g2_a21o_1
X_8627_ _8627_/Q _9686_/CLK _8627_/D fanout968/X VPWR VGND sg13g2_dfrbpq_1
XFILLER_10_736 VPWR VGND sg13g2_decap_8
X_8558_ _8559_/A _9272_/Q _8560_/A2 _8560_/B1 _9498_/Q VPWR VGND sg13g2_a22oi_1
XFILLER_30_22 VPWR VGND sg13g2_fill_1
X_7509_ _7509_/Y _9065_/Q _7818_/B _7819_/C VPWR VGND sg13g2_nand3b_1
X_8489_ _9249_/D _8488_/A _8489_/A2 _8488_/Y VPWR VGND sg13g2_o21ai_1
XFILLER_123_638 VPWR VGND sg13g2_decap_8
Xplace2181 _7650_/C _7802_/C VPWR VGND sg13g2_buf_1
XFILLER_30_77 VPWR VGND sg13g2_decap_4
XFILLER_30_88 VPWR VGND sg13g2_fill_1
Xplace2170 _5629_/B _4382_/Y VPWR VGND sg13g2_buf_1
Xplace2192 _5628_/B _9705_/Q VPWR VGND sg13g2_buf_1
XFILLER_89_563 VPWR VGND sg13g2_decap_8
XFILLER_49_405 VPWR VGND sg13g2_fill_1
XFILLER_103_362 VPWR VGND sg13g2_fill_2
XFILLER_49_438 VPWR VGND sg13g2_fill_1
XFILLER_76_235 VPWR VGND sg13g2_fill_1
XFILLER_57_482 VPWR VGND sg13g2_decap_4
XFILLER_72_474 VPWR VGND sg13g2_decap_4
XFILLER_44_154 VPWR VGND sg13g2_fill_2
XFILLER_32_327 VPWR VGND sg13g2_fill_2
XFILLER_25_390 VPWR VGND sg13g2_decap_8
XFILLER_32_349 VPWR VGND sg13g2_fill_1
XFILLER_9_545 VPWR VGND sg13g2_fill_2
XFILLER_65_7 VPWR VGND sg13g2_decap_8
XFILLER_114_627 VPWR VGND sg13g2_fill_2
XFILLER_5_784 VPWR VGND sg13g2_fill_2
XFILLER_68_703 VPWR VGND sg13g2_decap_4
XFILLER_67_224 VPWR VGND sg13g2_fill_1
XFILLER_121_181 VPWR VGND sg13g2_decap_8
XFILLER_95_599 VPWR VGND sg13g2_decap_8
XFILLER_36_600 VPWR VGND sg13g2_decap_4
X_7860_ _8936_/D _7417_/Y _8514_/B _7859_/Y VPWR VGND sg13g2_a21oi_1
XFILLER_75_290 VPWR VGND sg13g2_decap_8
XFILLER_36_622 VPWR VGND sg13g2_decap_8
X_6811_ _9559_/D _9592_/Q _9559_/Q _6813_/S VPWR VGND sg13g2_mux2_1
XFILLER_35_154 VPWR VGND sg13g2_decap_8
XFILLER_90_293 VPWR VGND sg13g2_decap_4
XFILLER_90_282 VPWR VGND sg13g2_fill_1
X_7791_ _7791_/X _7791_/A _7791_/B _7791_/C _7791_/D VPWR VGND sg13g2_and4_1
XFILLER_23_327 VPWR VGND sg13g2_decap_8
XFILLER_35_187 VPWR VGND sg13g2_fill_1
X_9530_ _9530_/Q _9582_/CLK _9530_/D _9530_/RESET_B VPWR VGND sg13g2_dfrbpq_1
X_6742_ _6742_/Y _9458_/Q _9457_/Q _9638_/Q _6742_/D VPWR VGND sg13g2_nor4_1
XFILLER_16_390 VPWR VGND sg13g2_decap_8
X_9461_ _9461_/Q _9675_/CLK _9461_/D place2446/X VPWR VGND sg13g2_dfrbpq_1
X_6673_ _6673_/Y _8655_/Q _5478_/Y _6672_/X VPWR VGND sg13g2_o21ai_1
XFILLER_31_382 VPWR VGND sg13g2_fill_2
X_5624_ _5624_/X _6915_/A _5625_/B _5629_/C _5629_/B VPWR VGND sg13g2_and4_1
X_9392_ _9392_/Q _9406_/CLK _9392_/D place2491/X VPWR VGND sg13g2_dfrbpq_1
X_8412_ _9206_/D _5374_/C _8411_/A _8411_/Y VPWR VGND sg13g2_o21ai_1
X_8343_ _8343_/Y _8343_/A _8343_/B VPWR VGND sg13g2_nand2_1
XFILLER_117_432 VPWR VGND sg13g2_fill_1
XFILLER_117_421 VPWR VGND sg13g2_decap_8
X_5555_ _5555_/Y _6621_/A _5579_/B VPWR VGND sg13g2_nand2_1
XFILLER_105_627 VPWR VGND sg13g2_decap_8
X_4506_ _7004_/C _7002_/B _4506_/B _4506_/C _7002_/D VPWR VGND sg13g2_nand4_1
X_8274_ _9137_/D _8563_/D _8083_/Y _8273_/Y VPWR VGND sg13g2_o21ai_1
X_5486_ _5486_/Y _6566_/D _6566_/A VPWR VGND sg13g2_nand2_1
X_7225_ _7225_/Y _7237_/A1 _9498_/Q _7237_/B1 _7237_/B2 VPWR VGND sg13g2_a22oi_1
X_4437_ _4447_/A _4437_/A _4437_/B VPWR VGND sg13g2_nand2_1
XFILLER_104_159 VPWR VGND sg13g2_fill_2
X_7156_ _7156_/Y _7156_/A _8871_/Q VPWR VGND sg13g2_nand2_1
XFILLER_86_522 VPWR VGND sg13g2_fill_2
X_4368_ _8729_/D _4368_/A VPWR VGND sg13g2_inv_1
XFILLER_76_29 VPWR VGND sg13g2_fill_1
X_6107_ _6107_/Y _6145_/B _6106_/Y _6039_/X VPWR VGND sg13g2_o21ai_1
X_4299_ _6071_/C _8816_/Q VPWR VGND sg13g2_inv_1
X_7087_ _7087_/Y _7187_/B _7187_/D _7105_/C VPWR VGND sg13g2_nand3_1
XFILLER_100_365 VPWR VGND sg13g2_fill_1
XFILLER_74_728 VPWR VGND sg13g2_decap_8
X_6038_ _6365_/C _6043_/B _6038_/B VPWR VGND sg13g2_nand2b_1
XFILLER_27_611 VPWR VGND sg13g2_decap_8
XFILLER_100_398 VPWR VGND sg13g2_decap_8
XFILLER_92_39 VPWR VGND sg13g2_fill_1
XFILLER_25_11 VPWR VGND sg13g2_fill_2
XFILLER_26_143 VPWR VGND sg13g2_fill_2
XFILLER_27_677 VPWR VGND sg13g2_fill_2
X_7989_ _7989_/Y _8009_/A _9005_/Q _8407_/C VPWR VGND sg13g2_nand3_1
XFILLER_26_176 VPWR VGND sg13g2_fill_2
X_9659_ _9659_/Q _9662_/CLK _9659_/D place2448/X VPWR VGND sg13g2_dfrbpq_1
XFILLER_41_10 VPWR VGND sg13g2_fill_2
XFILLER_6_559 VPWR VGND sg13g2_decap_4
XFILLER_6_548 VPWR VGND sg13g2_decap_8
XFILLER_123_402 VPWR VGND sg13g2_decap_4
XFILLER_123_435 VPWR VGND sg13g2_decap_8
XFILLER_123_468 VPWR VGND sg13g2_fill_2
XFILLER_77_511 VPWR VGND sg13g2_fill_2
XFILLER_103_181 VPWR VGND sg13g2_decap_8
XFILLER_18_600 VPWR VGND sg13g2_decap_8
XFILLER_45_430 VPWR VGND sg13g2_decap_8
XFILLER_73_772 VPWR VGND sg13g2_decap_4
XFILLER_45_441 VPWR VGND sg13g2_fill_1
XFILLER_17_187 VPWR VGND sg13g2_fill_2
XFILLER_60_499 VPWR VGND sg13g2_decap_8
XFILLER_119_708 VPWR VGND sg13g2_decap_8
XFILLER_41_691 VPWR VGND sg13g2_decap_4
XFILLER_118_218 VPWR VGND sg13g2_fill_2
X_5340_ _5340_/Y _5315_/Y _5339_/Y _5235_/A VPWR VGND sg13g2_a21oi_1
X_5271_ _5273_/A _5267_/Y _5242_/C _4324_/Y VPWR VGND sg13g2_o21ai_1
XFILLER_5_592 VPWR VGND sg13g2_fill_2
XFILLER_102_608 VPWR VGND sg13g2_decap_8
X_7010_ _8003_/A _7010_/A _7032_/C _7032_/D _7482_/C VPWR VGND sg13g2_nand4_1
Xhold2918 _8709_/D _8708_/Q VPWR VGND sg13g2_dlygate4sd3_1
XFILLER_99_179 VPWR VGND sg13g2_fill_1
Xhold2929 _8702_/D _8701_/Q VPWR VGND sg13g2_dlygate4sd3_1
XFILLER_87_319 VPWR VGND sg13g2_fill_2
XFILLER_83_525 VPWR VGND sg13g2_decap_8
X_8961_ _8961_/Q clkload4/A _8961_/D place2482/X VPWR VGND sg13g2_dfrbpq_1
X_7912_ _8969_/D _5354_/C _7953_/A _7911_/Y VPWR VGND sg13g2_o21ai_1
XFILLER_64_750 VPWR VGND sg13g2_fill_2
X_8892_ _8892_/Q _9253_/CLK _8892_/D place2426/X VPWR VGND sg13g2_dfrbpq_1
XFILLER_24_603 VPWR VGND sg13g2_decap_8
X_7843_ _7845_/A _9304_/Q _7843_/A2 _7843_/B1 _9336_/Q VPWR VGND sg13g2_a22oi_1
Xclkbuf_leaf_20_clk_i _9254_/CLK clkload1/A VPWR VGND sg13g2_buf_16
XFILLER_63_260 VPWR VGND sg13g2_decap_8
X_7774_ _8922_/D _8922_/Q _7773_/Y _7774_/S VPWR VGND sg13g2_mux2_1
X_4986_ _4986_/Y _5000_/B1 _5012_/B _4985_/Y VPWR VGND sg13g2_o21ai_1
XFILLER_24_658 VPWR VGND sg13g2_decap_8
X_6725_ _9493_/D _9534_/Q _9493_/Q _6726_/S VPWR VGND sg13g2_mux2_1
X_9513_ _9513_/Q _9587_/CLK _9513_/D _9513_/RESET_B VPWR VGND sg13g2_dfrbpq_1
Xclkbuf_leaf_35_clk_i _9153_/CLK clkbuf_3_0__f_clk_i/X VPWR VGND sg13g2_buf_16
X_9444_ _9444_/Q _9582_/CLK _9444_/D fanout983/X VPWR VGND sg13g2_dfrbpq_1
X_6656_ _9448_/D _6656_/A1 _6655_/Y _6654_/Y VPWR VGND sg13g2_o21ai_1
X_6587_ _6587_/Y _9428_/Q _6587_/B VPWR VGND sg13g2_nand2_1
X_9375_ _9375_/Q _9406_/CLK _9375_/D place2460/X VPWR VGND sg13g2_dfrbpq_1
X_5607_ _5607_/Y _9416_/Q _5621_/B _5500_/Y _8657_/Q VPWR VGND sg13g2_a22oi_1
X_5538_ _5538_/Y _9432_/Q _5591_/B _5601_/B1 _8634_/Q VPWR VGND sg13g2_a22oi_1
X_8326_ _9163_/D _8344_/A1 _8068_/Y _8325_/Y VPWR VGND sg13g2_o21ai_1
XFILLER_105_435 VPWR VGND sg13g2_fill_1
X_8257_ _8257_/Y _8257_/A _8279_/B VPWR VGND sg13g2_nand2_1
X_5469_ _5470_/A _5469_/A1 _8693_/Q _8694_/Q _5469_/B2 VPWR VGND sg13g2_a22oi_1
Xoutput2760 slave_rdata_o[6] _4837_/Y VPWR VGND sg13g2_buf_1
X_7208_ _7208_/Y _5366_/C _7222_/A2 _7207_/Y VPWR VGND sg13g2_o21ai_1
XFILLER_120_405 VPWR VGND sg13g2_decap_8
XFILLER_59_522 VPWR VGND sg13g2_decap_8
X_8188_ _9094_/D _8190_/A1 _8050_/Y _8187_/Y VPWR VGND sg13g2_o21ai_1
XFILLER_86_330 VPWR VGND sg13g2_decap_8
XFILLER_59_555 VPWR VGND sg13g2_decap_4
X_7139_ _8865_/D _6975_/X _7137_/Y _7138_/Y VPWR VGND sg13g2_o21ai_1
XFILLER_86_374 VPWR VGND sg13g2_fill_2
XFILLER_19_419 VPWR VGND sg13g2_decap_8
XFILLER_86_396 VPWR VGND sg13g2_fill_1
XFILLER_27_430 VPWR VGND sg13g2_fill_1
XFILLER_39_290 VPWR VGND sg13g2_fill_2
XFILLER_70_753 VPWR VGND sg13g2_fill_2
XFILLER_14_124 VPWR VGND sg13g2_fill_2
XFILLER_70_775 VPWR VGND sg13g2_decap_8
XFILLER_52_20 VPWR VGND sg13g2_decap_4
XFILLER_30_606 VPWR VGND sg13g2_decap_8
XFILLER_6_312 VPWR VGND sg13g2_decap_8
XFILLER_109_785 VPWR VGND sg13g2_decap_4
XFILLER_123_210 VPWR VGND sg13g2_decap_8
XFILLER_2_551 VPWR VGND sg13g2_fill_1
XFILLER_111_405 VPWR VGND sg13g2_fill_2
XFILLER_77_50 VPWR VGND sg13g2_decap_4
XFILLER_61_742 VPWR VGND sg13g2_decap_4
X_4840_ _4840_/X _9383_/Q _4770_/Y _4839_/Y VPWR VGND sg13g2_a21o_1
XFILLER_20_127 VPWR VGND sg13g2_decap_8
XFILLER_20_138 VPWR VGND sg13g2_fill_2
X_6510_ _6510_/Y _6510_/A _6510_/B VPWR VGND sg13g2_nand2_1
X_4771_ _4998_/A _4827_/B _4814_/B _4823_/B VPWR VGND sg13g2_o21ai_1
X_7490_ _7494_/A _7492_/A _9126_/Q _7490_/C VPWR VGND sg13g2_nor3_1
X_6441_ _6441_/Y _8884_/Q _6441_/A2 _6440_/X _6515_/B1 _6439_/Y VPWR VGND sg13g2_a221oi_1
X_9160_ _9160_/Q _9254_/CLK _9160_/D place2453/X VPWR VGND sg13g2_dfrbpq_1
X_6372_ _9381_/D _6364_/Y _6371_/Y _6362_/Y VPWR VGND sg13g2_a21oi_1
X_5323_ _8780_/D _5341_/A1 _5372_/C _5322_/Y _5336_/B2 VPWR VGND sg13g2_a22oi_1
XFILLER_54_0 VPWR VGND sg13g2_fill_2
X_8111_ _8111_/Y _8111_/A _8161_/B VPWR VGND sg13g2_nand2_1
X_9091_ _9091_/Q _9153_/CLK _9091_/D place2471/X VPWR VGND sg13g2_dfrbpq_1
X_5254_ _5254_/Y _5254_/A _5254_/B _5254_/C VPWR VGND sg13g2_nor3_1
X_8042_ _8042_/Y _8086_/A _9479_/Q _8056_/C _8086_/D VPWR VGND sg13g2_nand4_1
X_5185_ _5185_/Y _5185_/A _5185_/B VPWR VGND sg13g2_nand2_1
X_8944_ _8944_/Q _9603_/CLK _8944_/D place2431/X VPWR VGND sg13g2_dfrbpq_1
XFILLER_64_580 VPWR VGND sg13g2_decap_8
X_8875_ _8875_/Q _9407_/CLK _8875_/D place2490/X VPWR VGND sg13g2_dfrbpq_1
XFILLER_37_772 VPWR VGND sg13g2_decap_8
X_7826_ _7827_/A _9335_/Q _7826_/A2 _7846_/A2 _8862_/Q _7262_/X VPWR VGND sg13g2_a221oi_1
XFILLER_11_105 VPWR VGND sg13g2_fill_2
XFILLER_24_488 VPWR VGND sg13g2_decap_4
Xinput2603 _5859_/B1 master_rdata_i[3] VPWR VGND sg13g2_buf_1
X_7757_ _7757_/Y _7757_/A VPWR VGND sg13g2_inv_1
Xinput2614 _6043_/B slave_addr_i[6] VPWR VGND sg13g2_buf_1
Xinput2625 _7168_/B slave_wdata_i[11] VPWR VGND sg13g2_buf_1
X_4969_ _4969_/Y _4766_/A _4795_/B _4884_/X _4898_/C _4811_/Y VPWR VGND sg13g2_a221oi_1
X_7688_ _7692_/D _9167_/Q _7719_/B VPWR VGND sg13g2_nor2_1
X_6708_ _9476_/D _9517_/Q _9476_/Q _6733_/S VPWR VGND sg13g2_mux2_1
Xinput2636 _7204_/A slave_wdata_i[21] VPWR VGND sg13g2_buf_1
Xinput2647 _6979_/A slave_wdata_i[31] VPWR VGND sg13g2_buf_1
X_6639_ _6639_/Y _6642_/C _8645_/Q _9577_/Q _6655_/B2 VPWR VGND sg13g2_a22oi_1
X_9427_ _9427_/Q _9587_/CLK _9427_/D fanout978/X VPWR VGND sg13g2_dfrbpq_1
XFILLER_3_304 VPWR VGND sg13g2_fill_2
X_9358_ _9358_/Q clkload9/A _9358_/D place2505/X VPWR VGND sg13g2_dfrbpq_1
XFILLER_106_755 VPWR VGND sg13g2_fill_2
X_9289_ _9289_/Q _9305_/CLK _9289_/D place2415/X VPWR VGND sg13g2_dfrbpq_1
XFILLER_105_243 VPWR VGND sg13g2_fill_1
X_8309_ _8309_/Y _9155_/Q _8347_/B VPWR VGND sg13g2_nand2_1
XFILLER_106_788 VPWR VGND sg13g2_decap_4
XFILLER_87_683 VPWR VGND sg13g2_decap_8
XFILLER_28_761 VPWR VGND sg13g2_fill_1
XFILLER_103_70 VPWR VGND sg13g2_fill_2
XFILLER_63_41 VPWR VGND sg13g2_decap_8
XFILLER_15_444 VPWR VGND sg13g2_decap_8
XFILLER_70_561 VPWR VGND sg13g2_decap_4
XFILLER_63_52 VPWR VGND sg13g2_fill_1
XFILLER_43_775 VPWR VGND sg13g2_decap_8
XFILLER_8_14 VPWR VGND sg13g2_decap_8
XFILLER_30_436 VPWR VGND sg13g2_decap_8
XFILLER_42_285 VPWR VGND sg13g2_decap_8
XFILLER_11_694 VPWR VGND sg13g2_fill_2
XFILLER_116_519 VPWR VGND sg13g2_fill_2
XFILLER_6_153 VPWR VGND sg13g2_fill_2
XFILLER_7_687 VPWR VGND sg13g2_decap_4
XFILLER_6_186 VPWR VGND sg13g2_fill_2
XFILLER_112_736 VPWR VGND sg13g2_decap_4
XFILLER_112_703 VPWR VGND sg13g2_decap_8
XFILLER_97_403 VPWR VGND sg13g2_decap_8
XFILLER_84_108 VPWR VGND sg13g2_decap_8
XFILLER_38_503 VPWR VGND sg13g2_fill_2
XFILLER_93_642 VPWR VGND sg13g2_fill_2
XFILLER_81_804 VPWR VGND sg13g2_fill_1
X_6990_ _6992_/C _7690_/A _7741_/B _8825_/Q VPWR VGND sg13g2_nor3_1
X_5941_ _5941_/Y _5939_/Y _5940_/Y _5936_/Y _5937_/Y VPWR VGND sg13g2_a22oi_1
XFILLER_65_388 VPWR VGND sg13g2_fill_2
XFILLER_65_377 VPWR VGND sg13g2_decap_8
XFILLER_19_761 VPWR VGND sg13g2_fill_1
XFILLER_18_271 VPWR VGND sg13g2_decap_8
XFILLER_34_731 VPWR VGND sg13g2_decap_4
XFILLER_34_753 VPWR VGND sg13g2_fill_1
X_5872_ _5872_/Y _5837_/A2 _9476_/Q VPWR VGND sg13g2_nand2b_1
X_8660_ _8660_/Q _9686_/CLK _8660_/D fanout957/X VPWR VGND sg13g2_dfrbpq_1
XFILLER_33_263 VPWR VGND sg13g2_decap_8
X_7611_ _7611_/Y _7744_/A _7611_/B _7611_/C _7611_/D VPWR VGND sg13g2_nor4_1
XFILLER_21_425 VPWR VGND sg13g2_decap_8
XFILLER_21_436 VPWR VGND sg13g2_fill_1
X_8591_ _8591_/Q _9708_/CLK _8591_/D fanout948/X VPWR VGND sg13g2_dfrbpq_1
X_4823_ _4913_/A _4827_/B _4823_/B VPWR VGND sg13g2_nand2b_1
X_7542_ _7543_/D _9036_/Q _7544_/B _7541_/Y VPWR VGND sg13g2_o21ai_1
X_4754_ _4754_/Y _9377_/Q _8817_/Q VPWR VGND sg13g2_nand2b_1
X_7473_ _7473_/Y _8844_/Q _7579_/A2 _7737_/B1 _7473_/B2 _7461_/X VPWR VGND sg13g2_a221oi_1
XFILLER_119_357 VPWR VGND sg13g2_fill_2
X_4685_ _9659_/D _4685_/A _4685_/B VPWR VGND sg13g2_nor2_1
X_9212_ _9212_/Q _9254_/CLK _9212_/D place2402/X VPWR VGND sg13g2_dfrbpq_1
Xplace2500 place2500/X place2501/X VPWR VGND sg13g2_buf_1
Xplace2522 _6061_/A _6035_/A VPWR VGND sg13g2_buf_1
Xplace2511 _6408_/B _6035_/A VPWR VGND sg13g2_buf_1
Xplace1821 _8163_/B _8161_/B VPWR VGND sg13g2_buf_1
Xplace2533 _6158_/A _6037_/C VPWR VGND sg13g2_buf_1
Xplace1810 _8367_/A _8383_/A VPWR VGND sg13g2_buf_1
X_6424_ _9392_/D _6422_/Y _6279_/A _6423_/Y VPWR VGND sg13g2_a21oi_1
XFILLER_1_808 VPWR VGND sg13g2_fill_1
X_6355_ _6355_/Y _6379_/A1 _6346_/B _6355_/B1 VPWR VGND sg13g2_a21oi_1
Xplace1832 _7979_/A _8017_/A VPWR VGND sg13g2_buf_1
Xplace1854 _6392_/S _6253_/S VPWR VGND sg13g2_buf_1
X_9143_ _9143_/Q _9188_/CLK _9143_/D place2465/X VPWR VGND sg13g2_dfrbpq_1
Xplace1843 _7924_/A _7953_/A VPWR VGND sg13g2_buf_1
Xplace1876 _7883_/S _8514_/B VPWR VGND sg13g2_buf_1
X_5306_ _5329_/C _7729_/B _5306_/B _5306_/C VPWR VGND sg13g2_nor3_1
Xhold3202 _7022_/A _8829_/Q VPWR VGND sg13g2_dlygate4sd3_1
X_9074_ _9074_/Q _9198_/CLK _9074_/D place2439/X VPWR VGND sg13g2_dfrbpq_1
X_6286_ _6286_/X _8984_/Q _9046_/Q _9108_/Q _9170_/Q _6302_/S0 _6440_/S1 VPWR VGND
+ sg13g2_mux4_1
Xhold3224 _4726_/A _8741_/Q VPWR VGND sg13g2_dlygate4sd3_1
Xhold3213 _8301_/A _9151_/Q VPWR VGND sg13g2_dlygate4sd3_1
Xplace1865 _8488_/A _8486_/A VPWR VGND sg13g2_buf_1
Xplace1887 _7130_/A2 _7100_/A2 VPWR VGND sg13g2_buf_1
Xhold3235 _8422_/B _9215_/Q VPWR VGND sg13g2_dlygate4sd3_1
Xhold3246 _9668_/D _4368_/A VPWR VGND sg13g2_dlygate4sd3_1
X_5237_ _5360_/C _8414_/C _9487_/Q VPWR VGND sg13g2_nand2_1
X_8025_ _9022_/D _8054_/A1 _7889_/Y _8024_/Y VPWR VGND sg13g2_o21ai_1
Xplace1898 _6432_/S _6279_/A VPWR VGND sg13g2_buf_1
XFILLER_111_791 VPWR VGND sg13g2_fill_2
X_5168_ _5169_/B _5166_/Y _5139_/B _5164_/Y VPWR VGND sg13g2_o21ai_1
X_5099_ _5134_/A _5132_/D _5100_/B VPWR VGND sg13g2_nand2_1
XFILLER_83_141 VPWR VGND sg13g2_fill_1
XFILLER_56_333 VPWR VGND sg13g2_decap_8
XFILLER_29_547 VPWR VGND sg13g2_decap_4
X_8927_ _8927_/Q _9611_/CLK _8927_/D place2412/X VPWR VGND sg13g2_dfrbpq_1
XFILLER_16_219 VPWR VGND sg13g2_fill_2
XFILLER_17_56 VPWR VGND sg13g2_fill_1
XFILLER_44_517 VPWR VGND sg13g2_fill_1
Xdelaybuf_0_clk_jtg delaybuf_1_clk_jtg/A jtag_tck_i VPWR VGND sg13g2_buf_8
XFILLER_24_252 VPWR VGND sg13g2_decap_8
X_8858_ _8858_/Q _9407_/CLK _8858_/D place2455/X VPWR VGND sg13g2_dfrbpq_1
X_8789_ _8789_/Q _9219_/CLK _8789_/D place2402/X VPWR VGND sg13g2_dfrbpq_1
X_7809_ _7810_/D _8861_/Q _7846_/A2 _7809_/B1 _7809_/B2 VPWR VGND sg13g2_a22oi_1
XFILLER_24_296 VPWR VGND sg13g2_fill_1
XFILLER_40_745 VPWR VGND sg13g2_decap_8
XFILLER_4_635 VPWR VGND sg13g2_decap_8
XFILLER_3_101 VPWR VGND sg13g2_decap_8
XFILLER_3_189 VPWR VGND sg13g2_decap_8
XFILLER_94_406 VPWR VGND sg13g2_fill_2
XFILLER_66_119 VPWR VGND sg13g2_fill_1
XFILLER_47_311 VPWR VGND sg13g2_decap_8
XFILLER_47_333 VPWR VGND sg13g2_decap_4
XFILLER_90_612 VPWR VGND sg13g2_fill_1
XFILLER_47_388 VPWR VGND sg13g2_decap_8
XFILLER_35_528 VPWR VGND sg13g2_decap_8
XFILLER_95_7 VPWR VGND sg13g2_decap_8
XFILLER_31_745 VPWR VGND sg13g2_fill_2
XFILLER_43_583 VPWR VGND sg13g2_decap_8
X_4470_ _4470_/Y hold3037/X _4470_/B VPWR VGND sg13g2_nand2b_1
XFILLER_7_462 VPWR VGND sg13g2_decap_4
X_6140_ _6140_/Y _6379_/A1 _6346_/B _6140_/B1 VPWR VGND sg13g2_a21oi_1
XFILLER_112_544 VPWR VGND sg13g2_decap_8
XFILLER_98_789 VPWR VGND sg13g2_fill_1
XFILLER_85_406 VPWR VGND sg13g2_decap_8
X_6071_ _6071_/Y _6071_/A _6071_/B _6071_/C _6071_/D VPWR VGND sg13g2_nor4_1
XFILLER_112_588 VPWR VGND sg13g2_fill_2
X_5022_ _5065_/C _5160_/B _9260_/Q VPWR VGND sg13g2_nand2_1
XFILLER_93_450 VPWR VGND sg13g2_decap_8
XFILLER_66_653 VPWR VGND sg13g2_fill_2
XFILLER_65_152 VPWR VGND sg13g2_decap_4
XFILLER_26_517 VPWR VGND sg13g2_decap_8
XFILLER_0_70 VPWR VGND sg13g2_decap_8
XFILLER_38_399 VPWR VGND sg13g2_decap_4
X_6973_ _6975_/B _7010_/A _6972_/Y _6959_/Y VPWR VGND sg13g2_a21oi_1
X_5924_ _5925_/B _5954_/A _5932_/B _5992_/A _5924_/D VPWR VGND sg13g2_nand4_1
X_8712_ _8712_/Q _9662_/CLK _8712_/D place2445/X VPWR VGND sg13g2_dfrbpq_1
XFILLER_80_144 VPWR VGND sg13g2_fill_1
XFILLER_53_369 VPWR VGND sg13g2_decap_8
X_9692_ _9692_/Q _9692_/CLK _9692_/D place2493/X VPWR VGND sg13g2_dfrbpq_1
XFILLER_34_561 VPWR VGND sg13g2_fill_2
X_8643_ _8643_/Q _9449_/CLK _8643_/D fanout983/X VPWR VGND sg13g2_dfrbpq_1
X_5855_ _9308_/D _9308_/Q _6006_/S _5854_/Y VPWR VGND sg13g2_a21o_1
XFILLER_61_391 VPWR VGND sg13g2_fill_1
X_4806_ _4807_/C _4793_/B _4903_/C _4774_/Y _4924_/B VPWR VGND sg13g2_a22oi_1
X_8574_ _9279_/D _5872_/Y _8563_/X _8573_/Y VPWR VGND sg13g2_o21ai_1
X_5786_ _5786_/Y _6523_/A _5785_/C _5787_/C VPWR VGND sg13g2_a21oi_1
XFILLER_119_14 VPWR VGND sg13g2_decap_8
X_4737_ _4737_/Y _6071_/A _9690_/Q VPWR VGND sg13g2_nor2_1
X_7525_ _7525_/Y _7525_/A _7525_/B _7525_/C _7525_/D VPWR VGND sg13g2_nor4_1
X_4668_ _9644_/D _6953_/S _4666_/B _4667_/Y VPWR VGND sg13g2_o21ai_1
X_7456_ _7458_/C _8748_/Q _5412_/C _7455_/Y VPWR VGND sg13g2_a21oi_1
Xplace2330 _4944_/A _4903_/B VPWR VGND sg13g2_buf_1
Xplace2341 _5932_/D _5924_/D VPWR VGND sg13g2_buf_1
Xplace2352 _8061_/A _8414_/C VPWR VGND sg13g2_buf_1
Xplace2363 _8496_/B _6959_/B VPWR VGND sg13g2_buf_1
X_6407_ _6407_/Y _6124_/X _6189_/D _6173_/C _6438_/D VPWR VGND sg13g2_a22oi_1
Xplace2374 _8444_/C _5203_/A VPWR VGND sg13g2_buf_1
Xplace2396 place2396/X place2398/X VPWR VGND sg13g2_buf_1
XFILLER_88_200 VPWR VGND sg13g2_decap_8
X_4599_ _4647_/C _9670_/Q _9673_/Q _9672_/Q VPWR VGND sg13g2_nor3_1
X_7387_ _7389_/C _7404_/C _8997_/Q _7387_/C VPWR VGND sg13g2_nor3_1
X_9126_ _9126_/Q _9188_/CLK _9126_/D place2467/X VPWR VGND sg13g2_dfrbpq_1
Xplace2385 _6507_/A2 _6173_/A VPWR VGND sg13g2_buf_1
Xhold3021 hold3021/X _8709_/Q VPWR VGND sg13g2_dlygate4sd3_1
XFILLER_103_544 VPWR VGND sg13g2_decap_4
XFILLER_89_734 VPWR VGND sg13g2_fill_2
X_6338_ _6338_/Y _8589_/A _6338_/B _6338_/C _6338_/D VPWR VGND sg13g2_nor4_1
XFILLER_0_115 VPWR VGND sg13g2_decap_8
Xhold3010 _8191_/A _9096_/Q VPWR VGND sg13g2_dlygate4sd3_1
Xhold3032 _5634_/B2 _8620_/Q VPWR VGND sg13g2_dlygate4sd3_1
XFILLER_88_244 VPWR VGND sg13g2_decap_8
XFILLER_76_406 VPWR VGND sg13g2_fill_2
Xhold3043 _6304_/B1 _9371_/Q VPWR VGND sg13g2_dlygate4sd3_1
X_6269_ _6271_/B _9234_/Q _6322_/B VPWR VGND sg13g2_nor2b_1
X_9057_ _9057_/Q clkload5/A _9057_/D place2498/X VPWR VGND sg13g2_dfrbpq_1
Xhold3065 _8173_/A _9087_/Q VPWR VGND sg13g2_dlygate4sd3_1
Xhold3054 _9680_/D _4571_/Y VPWR VGND sg13g2_dlygate4sd3_1
XFILLER_48_108 VPWR VGND sg13g2_decap_8
Xhold3076 _6614_/A _9436_/Q VPWR VGND sg13g2_dlygate4sd3_1
Xhold3087 _8070_/A _9040_/Q VPWR VGND sg13g2_dlygate4sd3_1
Xhold3098 _4401_/A1 _8670_/Q VPWR VGND sg13g2_dlygate4sd3_1
XFILLER_29_300 VPWR VGND sg13g2_decap_4
X_8008_ _9014_/D _5368_/C _8007_/A _8007_/Y VPWR VGND sg13g2_o21ai_1
XFILLER_48_119 VPWR VGND sg13g2_fill_1
XFILLER_69_491 VPWR VGND sg13g2_fill_1
XFILLER_57_642 VPWR VGND sg13g2_fill_1
XFILLER_29_355 VPWR VGND sg13g2_fill_2
XFILLER_84_472 VPWR VGND sg13g2_decap_4
XFILLER_84_450 VPWR VGND sg13g2_decap_8
XFILLER_72_656 VPWR VGND sg13g2_decap_8
XFILLER_17_539 VPWR VGND sg13g2_fill_2
XFILLER_72_667 VPWR VGND sg13g2_fill_2
XFILLER_71_144 VPWR VGND sg13g2_decap_8
XFILLER_13_701 VPWR VGND sg13g2_decap_4
XFILLER_25_561 VPWR VGND sg13g2_fill_2
XFILLER_13_734 VPWR VGND sg13g2_decap_4
XFILLER_44_65 VPWR VGND sg13g2_decap_4
XFILLER_12_233 VPWR VGND sg13g2_fill_2
XFILLER_13_756 VPWR VGND sg13g2_decap_4
XFILLER_40_553 VPWR VGND sg13g2_decap_8
XFILLER_100_60 VPWR VGND sg13g2_decap_8
XFILLER_12_277 VPWR VGND sg13g2_fill_2
XFILLER_121_0 VPWR VGND sg13g2_decap_8
XFILLER_8_259 VPWR VGND sg13g2_fill_2
XFILLER_60_75 VPWR VGND sg13g2_decap_8
XFILLER_95_759 VPWR VGND sg13g2_decap_8
XFILLER_95_748 VPWR VGND sg13g2_fill_2
XFILLER_79_277 VPWR VGND sg13g2_fill_1
XFILLER_85_61 VPWR VGND sg13g2_decap_8
XFILLER_10_7 VPWR VGND sg13g2_decap_8
XFILLER_0_693 VPWR VGND sg13g2_decap_8
XFILLER_75_461 VPWR VGND sg13g2_decap_8
XFILLER_63_623 VPWR VGND sg13g2_fill_2
XFILLER_90_420 VPWR VGND sg13g2_decap_8
XFILLER_62_144 VPWR VGND sg13g2_fill_2
XFILLER_31_531 VPWR VGND sg13g2_decap_8
XFILLER_31_542 VPWR VGND sg13g2_fill_2
X_5640_ _5640_/Y _5640_/A _5640_/B VPWR VGND sg13g2_nor2_1
X_5571_ _5571_/Y _8646_/Q _5592_/A2 _5580_/B1 _8645_/Q VPWR VGND sg13g2_a22oi_1
XFILLER_117_603 VPWR VGND sg13g2_decap_8
XFILLER_117_614 VPWR VGND sg13g2_fill_2
X_4522_ _4525_/B _4512_/Y _4521_/Y _4520_/Y VPWR VGND sg13g2_a21oi_1
X_7310_ _7313_/A _7386_/A _7351_/B _9086_/Q VPWR VGND sg13g2_nor3_1
X_8290_ _9145_/D _8314_/A1 _8022_/Y _8289_/Y VPWR VGND sg13g2_o21ai_1
X_7241_ _7241_/X _6523_/A _5404_/C _4542_/Y VPWR VGND sg13g2_a21o_1
X_4453_ _6064_/D _6018_/A _6018_/B _6451_/A VPWR VGND sg13g2_nand3_1
XFILLER_116_157 VPWR VGND sg13g2_decap_8
XFILLER_104_308 VPWR VGND sg13g2_fill_1
X_7172_ _7172_/Y _7172_/A _7172_/B _7207_/C _7179_/D VPWR VGND sg13g2_nand4_1
X_4384_ _4389_/B _9627_/Q _5416_/B VPWR VGND sg13g2_nor2b_1
X_6123_ _6397_/A _6369_/A _6369_/B _6369_/D _6262_/B VPWR VGND sg13g2_nand4_1
XFILLER_105_27 VPWR VGND sg13g2_decap_4
XFILLER_58_417 VPWR VGND sg13g2_fill_2
X_6054_ _6055_/A _6064_/D _6019_/A _6275_/B VPWR VGND sg13g2_o21ai_1
X_5005_ _5005_/Y _5005_/A _5005_/B VPWR VGND sg13g2_nor2_1
XFILLER_66_472 VPWR VGND sg13g2_decap_4
XFILLER_53_111 VPWR VGND sg13g2_fill_2
XFILLER_26_325 VPWR VGND sg13g2_decap_8
X_6956_ _9207_/D _9689_/Q _9207_/Q _6956_/S VPWR VGND sg13g2_mux2_1
XFILLER_42_807 VPWR VGND sg13g2_fill_2
X_5907_ _5909_/A _5907_/A1 _5945_/A _5906_/Y VPWR VGND sg13g2_o21ai_1
XFILLER_81_497 VPWR VGND sg13g2_fill_1
XFILLER_53_177 VPWR VGND sg13g2_decap_8
X_6887_ _6887_/X _8917_/Q _8949_/Q _6909_/S VPWR VGND sg13g2_mux2_1
X_9675_ _9675_/Q _9675_/CLK _9675_/D place2450/X VPWR VGND sg13g2_dfrbpq_1
X_5838_ _5838_/Y _5830_/Y _5835_/X _5935_/A2 VPWR VGND sg13g2_a21oi_1
X_8626_ _8626_/Q _9678_/CLK _8626_/D fanout978/X VPWR VGND sg13g2_dfrbpq_1
X_8557_ _9271_/D _8557_/A VPWR VGND sg13g2_inv_1
X_5769_ _5769_/Y _9329_/Q _5769_/B VPWR VGND sg13g2_nand2b_1
XFILLER_6_708 VPWR VGND sg13g2_fill_2
XFILLER_108_636 VPWR VGND sg13g2_decap_8
XFILLER_108_614 VPWR VGND sg13g2_decap_8
XFILLER_5_218 VPWR VGND sg13g2_fill_1
X_7508_ _7511_/C _7819_/C _7818_/B _8972_/Q VPWR VGND sg13g2_nor3_1
XFILLER_107_113 VPWR VGND sg13g2_decap_8
X_8488_ _8488_/Y _8488_/A _9249_/Q _8492_/C VPWR VGND sg13g2_nand3_1
XFILLER_123_617 VPWR VGND sg13g2_decap_8
XFILLER_107_168 VPWR VGND sg13g2_decap_8
X_7439_ _8905_/D _7438_/Y _7576_/S _7419_/Y VPWR VGND sg13g2_a21oi_1
Xplace2182 _7802_/C _7747_/C VPWR VGND sg13g2_buf_1
Xplace2160 _7724_/B _7670_/B VPWR VGND sg13g2_buf_1
Xplace2171 _5012_/A _4782_/D VPWR VGND sg13g2_buf_1
XFILLER_116_680 VPWR VGND sg13g2_decap_8
XFILLER_1_413 VPWR VGND sg13g2_decap_4
Xplace2193 _4591_/B _9695_/Q VPWR VGND sg13g2_buf_1
X_9109_ _9109_/Q _9199_/CLK _9109_/D place2433/X VPWR VGND sg13g2_dfrbpq_1
XFILLER_89_586 VPWR VGND sg13g2_decap_8
XFILLER_85_781 VPWR VGND sg13g2_fill_1
XFILLER_17_303 VPWR VGND sg13g2_fill_1
Xclkbuf_0_jtag_tck_i_regs clkbuf_0_jtag_tck_i_regs/X clkbuf_regs_0_clk_jtg/X VPWR
+ VGND sg13g2_buf_8
XFILLER_45_667 VPWR VGND sg13g2_decap_8
XFILLER_60_626 VPWR VGND sg13g2_decap_4
XFILLER_71_30 VPWR VGND sg13g2_decap_8
XFILLER_9_524 VPWR VGND sg13g2_decap_8
XFILLER_40_361 VPWR VGND sg13g2_fill_1
XFILLER_58_7 VPWR VGND sg13g2_decap_4
XFILLER_4_240 VPWR VGND sg13g2_decap_8
XFILLER_113_127 VPWR VGND sg13g2_decap_8
XFILLER_113_116 VPWR VGND sg13g2_fill_1
XFILLER_4_273 VPWR VGND sg13g2_fill_2
XFILLER_96_93 VPWR VGND sg13g2_fill_2
XFILLER_95_578 VPWR VGND sg13g2_decap_8
XFILLER_76_781 VPWR VGND sg13g2_fill_2
XFILLER_91_740 VPWR VGND sg13g2_fill_1
XFILLER_35_111 VPWR VGND sg13g2_fill_1
XFILLER_36_645 VPWR VGND sg13g2_fill_1
XFILLER_91_773 VPWR VGND sg13g2_decap_8
X_6810_ _9558_/D _9591_/Q _9558_/Q _6839_/S VPWR VGND sg13g2_mux2_1
XFILLER_91_784 VPWR VGND sg13g2_fill_2
X_7790_ _7791_/B _9301_/Q _7828_/A2 _6972_/Y _8891_/Q _5412_/C VPWR VGND sg13g2_a221oi_1
X_6741_ _6741_/Y _9460_/Q _6741_/B VPWR VGND sg13g2_nor2_1
X_9460_ _9460_/Q _9662_/CLK _9460_/D place2445/X VPWR VGND sg13g2_dfrbpq_1
X_6672_ _6672_/X _6672_/A _9587_/Q _6672_/C VPWR VGND sg13g2_or3_1
XFILLER_84_0 VPWR VGND sg13g2_decap_8
X_9391_ _9391_/Q _9406_/CLK _9391_/D place2390/X VPWR VGND sg13g2_dfrbpq_1
X_8411_ _8411_/Y _8411_/A _9206_/Q _8411_/C VPWR VGND sg13g2_nand3_1
X_5623_ _8662_/D _5622_/Y _5621_/Y _5623_/B1 VPWR VGND sg13g2_a21oi_1
X_8342_ _9171_/D _8346_/A1 _8092_/Y _8341_/Y VPWR VGND sg13g2_o21ai_1
X_5554_ _8639_/D _5553_/Y _5552_/Y _5587_/B1 VPWR VGND sg13g2_a21oi_1
X_9532__2848 _9532_/RESET_B VPWR VGND sg13g2_tiehi
X_4505_ _5073_/A _8743_/D _6982_/A VPWR VGND sg13g2_nor2_1
X_8273_ _8273_/Y _8273_/A _8279_/B VPWR VGND sg13g2_nand2_1
X_5485_ _5494_/B _5484_/Y _9694_/Q _5482_/Y _5628_/B _9454_/Q VPWR VGND sg13g2_a221oi_1
XFILLER_104_116 VPWR VGND sg13g2_decap_8
X_7224_ _7224_/Y _7236_/A _7224_/B _8496_/B _7236_/D VPWR VGND sg13g2_nand4_1
XFILLER_6_80 VPWR VGND sg13g2_fill_1
X_4436_ _4437_/B _4436_/A _4436_/B _4436_/C _4436_/D VPWR VGND sg13g2_nor4_1
X_4367_ _4368_/A _9666_/Q _4365_/B _4366_/Y VPWR VGND sg13g2_o21ai_1
X_7155_ _7155_/Y _8039_/D _6977_/Y _7132_/Y _4435_/C VPWR VGND sg13g2_a22oi_1
XFILLER_113_694 VPWR VGND sg13g2_fill_1
XFILLER_86_501 VPWR VGND sg13g2_decap_8
X_6106_ _6106_/Y _6079_/A _6105_/Y _6090_/Y VPWR VGND sg13g2_a21oi_1
X_4298_ _6033_/C _6064_/B VPWR VGND sg13g2_inv_1
X_7086_ _7110_/S _7187_/D _6962_/Y _6964_/Y VPWR VGND sg13g2_o21ai_1
X_6037_ _6038_/B _6037_/A _6348_/D _6037_/C VPWR VGND sg13g2_nand3_1
XFILLER_26_111 VPWR VGND sg13g2_decap_8
XFILLER_27_645 VPWR VGND sg13g2_fill_1
XFILLER_82_751 VPWR VGND sg13g2_fill_2
XFILLER_82_740 VPWR VGND sg13g2_fill_2
XFILLER_81_250 VPWR VGND sg13g2_fill_2
XFILLER_54_475 VPWR VGND sg13g2_decap_8
X_7988_ _9004_/D _5358_/C _8019_/A _7987_/Y VPWR VGND sg13g2_o21ai_1
X_6939_ _6939_/X _9632_/Q _6939_/B _6939_/C VPWR VGND sg13g2_and3_1
X_9658_ _9658_/Q _9662_/CLK _9658_/D place2447/X VPWR VGND sg13g2_dfrbpq_1
XFILLER_22_350 VPWR VGND sg13g2_fill_1
XFILLER_22_383 VPWR VGND sg13g2_fill_1
X_8609_ _8609_/Q _9708_/CLK _8609_/D fanout948/X VPWR VGND sg13g2_dfrbpq_1
X_9589_ _9589_/Q _9603_/CLK _9589_/D _9589_/RESET_B VPWR VGND sg13g2_dfrbpq_1
XFILLER_6_505 VPWR VGND sg13g2_decap_8
XFILLER_108_455 VPWR VGND sg13g2_fill_2
XFILLER_108_499 VPWR VGND sg13g2_fill_1
X_9508__2872 _9508_/RESET_B VPWR VGND sg13g2_tiehi
XFILLER_1_232 VPWR VGND sg13g2_fill_2
XFILLER_2_755 VPWR VGND sg13g2_decap_8
XFILLER_104_672 VPWR VGND sg13g2_decap_8
XFILLER_103_160 VPWR VGND sg13g2_decap_8
XFILLER_2_777 VPWR VGND sg13g2_decap_8
XFILLER_103_193 VPWR VGND sg13g2_decap_8
XFILLER_77_556 VPWR VGND sg13g2_decap_8
XFILLER_2_49 VPWR VGND sg13g2_decap_8
XFILLER_66_63 VPWR VGND sg13g2_decap_4
XFILLER_65_729 VPWR VGND sg13g2_fill_2
XFILLER_65_718 VPWR VGND sg13g2_fill_2
XFILLER_58_781 VPWR VGND sg13g2_fill_1
XFILLER_45_453 VPWR VGND sg13g2_decap_8
Xclkbuf_leaf_1_clk_i clkload6/A clkload0/A VPWR VGND sg13g2_buf_16
XFILLER_33_626 VPWR VGND sg13g2_decap_4
X_9582__2808 _9582_/RESET_B VPWR VGND sg13g2_tiehi
XFILLER_82_51 VPWR VGND sg13g2_fill_2
XFILLER_60_456 VPWR VGND sg13g2_fill_2
XFILLER_32_147 VPWR VGND sg13g2_fill_2
XFILLER_33_659 VPWR VGND sg13g2_decap_8
XFILLER_82_95 VPWR VGND sg13g2_decap_8
XFILLER_60_478 VPWR VGND sg13g2_decap_4
XFILLER_13_350 VPWR VGND sg13g2_fill_2
XFILLER_13_372 VPWR VGND sg13g2_fill_2
XFILLER_114_414 VPWR VGND sg13g2_fill_2
XFILLER_99_103 VPWR VGND sg13g2_decap_4
X_5270_ _5270_/Y _8426_/C _9492_/Q VPWR VGND sg13g2_nand2_1
XFILLER_5_571 VPWR VGND sg13g2_decap_8
XFILLER_99_158 VPWR VGND sg13g2_decap_8
Xhold2919 _8712_/D _8711_/Q VPWR VGND sg13g2_dlygate4sd3_1
XFILLER_68_501 VPWR VGND sg13g2_fill_1
XFILLER_83_504 VPWR VGND sg13g2_fill_2
XFILLER_68_578 VPWR VGND sg13g2_fill_1
XFILLER_56_718 VPWR VGND sg13g2_decap_8
X_8960_ _8960_/Q _9242_/CLK _8960_/D place2482/X VPWR VGND sg13g2_dfrbpq_1
XFILLER_83_537 VPWR VGND sg13g2_decap_4
X_7911_ _7911_/Y _7953_/A _8969_/Q _8371_/C VPWR VGND sg13g2_nand3_1
X_8891_ _8891_/Q _9253_/CLK _8891_/D place2456/X VPWR VGND sg13g2_dfrbpq_1
XFILLER_24_637 VPWR VGND sg13g2_decap_8
XFILLER_36_497 VPWR VGND sg13g2_fill_2
X_7842_ _7842_/Y _7836_/Y _7841_/Y _8086_/D VPWR VGND sg13g2_o21ai_1
X_7773_ _7773_/Y _7811_/A _7811_/B _7811_/C _7773_/D VPWR VGND sg13g2_nor4_1
X_4985_ _4985_/Y _9402_/Q _4972_/B _4984_/Y VPWR VGND sg13g2_a21oi_1
XFILLER_23_147 VPWR VGND sg13g2_decap_8
X_6724_ _9492_/D _9533_/Q _9492_/Q _6726_/S VPWR VGND sg13g2_mux2_1
X_9558__2832 _9558_/RESET_B VPWR VGND sg13g2_tiehi
X_9512_ _9512_/Q _9686_/CLK _9512_/D _9512_/RESET_B VPWR VGND sg13g2_dfrbpq_1
X_9443_ _9443_/Q _9567_/CLK _9443_/D fanout984/X VPWR VGND sg13g2_dfrbpq_1
XFILLER_32_692 VPWR VGND sg13g2_decap_4
X_6655_ _6655_/Y _6622_/C _8650_/Q _9582_/Q _6655_/B2 VPWR VGND sg13g2_a22oi_1
X_6586_ _9427_/D _6670_/A1 _6585_/Y _6584_/Y VPWR VGND sg13g2_o21ai_1
X_9374_ _9374_/Q clkload9/A _9374_/D place2491/X VPWR VGND sg13g2_dfrbpq_1
X_5606_ _5606_/Y _5625_/B _6541_/A _8658_/Q _6541_/B VPWR VGND sg13g2_nand4_1
XFILLER_118_764 VPWR VGND sg13g2_decap_4
X_5537_ _5537_/Y _5597_/A _5597_/B _8635_/Q _5597_/D VPWR VGND sg13g2_nand4_1
X_8325_ _8325_/Y _8325_/A _8343_/B VPWR VGND sg13g2_nand2_1
XFILLER_105_425 VPWR VGND sg13g2_fill_1
X_8256_ _9128_/D _8288_/A1 _7920_/Y _8255_/Y VPWR VGND sg13g2_o21ai_1
Xoutput2750 slave_rdata_o[26] _4986_/Y VPWR VGND sg13g2_buf_1
XFILLER_87_29 VPWR VGND sg13g2_fill_1
X_5468_ _8692_/D _5468_/A _5468_/B_N VPWR VGND sg13g2_nor2b_1
Xoutput2761 slave_rdata_o[7] _4840_/X VPWR VGND sg13g2_buf_1
X_7207_ _7207_/Y _7207_/A _7207_/B _7207_/C _7221_/D VPWR VGND sg13g2_nand4_1
X_5399_ _5400_/B _7704_/A _7705_/A _7269_/A VPWR VGND sg13g2_nand3_1
XFILLER_59_501 VPWR VGND sg13g2_decap_8
X_8187_ _8187_/Y _8187_/A _8191_/B VPWR VGND sg13g2_nand2_1
X_4419_ _6254_/C _8446_/B _9246_/Q _6333_/B VPWR VGND sg13g2_nor3_1
X_7138_ _7138_/Y _7156_/A _8865_/Q VPWR VGND sg13g2_nand2_1
XFILLER_101_675 VPWR VGND sg13g2_decap_8
XFILLER_100_130 VPWR VGND sg13g2_decap_4
XFILLER_86_364 VPWR VGND sg13g2_fill_2
XFILLER_59_567 VPWR VGND sg13g2_fill_2
X_7069_ _7069_/Y _5354_/C _6967_/Y _7068_/Y VPWR VGND sg13g2_o21ai_1
XFILLER_100_185 VPWR VGND sg13g2_decap_4
XFILLER_46_228 VPWR VGND sg13g2_decap_4
XFILLER_82_581 VPWR VGND sg13g2_decap_8
XFILLER_70_732 VPWR VGND sg13g2_decap_8
XFILLER_14_158 VPWR VGND sg13g2_decap_8
XFILLER_30_629 VPWR VGND sg13g2_decap_8
XFILLER_6_302 VPWR VGND sg13g2_fill_1
XFILLER_109_742 VPWR VGND sg13g2_fill_1
XFILLER_109_764 VPWR VGND sg13g2_decap_8
XFILLER_123_266 VPWR VGND sg13g2_decap_4
XFILLER_77_95 VPWR VGND sg13g2_fill_2
XFILLER_46_762 VPWR VGND sg13g2_decap_4
XFILLER_73_570 VPWR VGND sg13g2_decap_8
XFILLER_33_401 VPWR VGND sg13g2_decap_4
XFILLER_33_412 VPWR VGND sg13g2_fill_1
XFILLER_45_261 VPWR VGND sg13g2_fill_1
XFILLER_46_773 VPWR VGND sg13g2_decap_8
XFILLER_60_220 VPWR VGND sg13g2_fill_2
XFILLER_45_283 VPWR VGND sg13g2_decap_8
XFILLER_60_253 VPWR VGND sg13g2_decap_8
X_4770_ _4770_/Y _8818_/Q _8817_/Q VPWR VGND sg13g2_nor2b_1
XFILLER_20_106 VPWR VGND sg13g2_fill_2
X_6440_ _6440_/X _9010_/Q _9072_/Q _9134_/Q _9196_/Q _6440_/S0 _6440_/S1 VPWR VGND
+ sg13g2_mux4_1
X_6371_ _6371_/Y _6371_/A _6371_/B _6371_/C VPWR VGND sg13g2_nor3_1
X_5322_ _5322_/Y _5322_/A _5322_/B VPWR VGND sg13g2_nand2_1
X_8110_ _9055_/D _8120_/A1 _8029_/Y _8109_/Y VPWR VGND sg13g2_o21ai_1
XFILLER_88_607 VPWR VGND sg13g2_decap_8
X_9090_ _9090_/Q _9183_/CLK _9090_/D place2472/X VPWR VGND sg13g2_dfrbpq_1
XFILLER_47_0 VPWR VGND sg13g2_decap_4
X_5253_ _5256_/A _5254_/B _5254_/C _5254_/A VPWR VGND sg13g2_o21ai_1
X_8041_ _8041_/Y _8041_/A _8099_/B VPWR VGND sg13g2_nand2_1
X_5184_ _5352_/C _8407_/C _9479_/Q VPWR VGND sg13g2_nand2_1
XFILLER_96_673 VPWR VGND sg13g2_decap_8
XFILLER_56_504 VPWR VGND sg13g2_fill_1
XFILLER_113_27 VPWR VGND sg13g2_decap_8
XFILLER_96_695 VPWR VGND sg13g2_decap_8
XFILLER_68_397 VPWR VGND sg13g2_decap_8
X_8943_ _8943_/Q _9611_/CLK _8943_/D place2416/X VPWR VGND sg13g2_dfrbpq_1
X_9482__2898 _9482_/RESET_B VPWR VGND sg13g2_tiehi
XFILLER_83_367 VPWR VGND sg13g2_fill_1
XFILLER_71_518 VPWR VGND sg13g2_fill_2
X_8874_ _8874_/Q clkload9/A _8874_/D place2492/X VPWR VGND sg13g2_dfrbpq_1
XFILLER_36_261 VPWR VGND sg13g2_decap_8
X_7825_ _7827_/C _9887_/A _7825_/A2 _7825_/B1 _7825_/B2 VPWR VGND sg13g2_a22oi_1
XFILLER_52_787 VPWR VGND sg13g2_fill_1
Xinput2604 _5867_/B1 master_rdata_i[4] VPWR VGND sg13g2_buf_1
X_7756_ _7757_/A _9271_/Q _8515_/D _7794_/B1 _8890_/Q VPWR VGND sg13g2_a22oi_1
Xinput2615 _6046_/D slave_addr_i[7] VPWR VGND sg13g2_buf_1
X_4968_ _4968_/Y _4944_/A _9368_/Q VPWR VGND sg13g2_nand2b_1
X_7687_ _7687_/Y _7744_/A _7687_/B _7687_/C _7687_/D VPWR VGND sg13g2_nor4_1
X_6707_ _9475_/D _9516_/Q _9475_/Q _6710_/S VPWR VGND sg13g2_mux2_1
Xinput2648 _4436_/C slave_wdata_i[3] VPWR VGND sg13g2_buf_1
Xinput2626 _7172_/A slave_wdata_i[12] VPWR VGND sg13g2_buf_1
Xinput2637 _7207_/A slave_wdata_i[22] VPWR VGND sg13g2_buf_1
X_4899_ _4899_/Y _4998_/B _4937_/C _4899_/C VPWR VGND sg13g2_nor3_1
X_6638_ _6638_/Y _6638_/A _6651_/B VPWR VGND sg13g2_nand2_1
X_9426_ _9426_/Q _9678_/CLK _9426_/D fanout978/X VPWR VGND sg13g2_dfrbpq_1
X_9357_ _9357_/Q clkload9/A _9357_/D place2490/X VPWR VGND sg13g2_dfrbpq_1
XFILLER_106_734 VPWR VGND sg13g2_decap_8
XFILLER_105_200 VPWR VGND sg13g2_fill_1
X_6569_ _6569_/Y _6569_/A _6569_/B _6569_/C _6569_/D VPWR VGND sg13g2_nand4_1
X_8308_ _9154_/D _8314_/A1 _7909_/Y _8307_/Y VPWR VGND sg13g2_o21ai_1
X_9288_ _9288_/Q _9304_/CLK _9288_/D place2410/X VPWR VGND sg13g2_dfrbpq_1
XFILLER_78_117 VPWR VGND sg13g2_decap_4
X_8239_ _8239_/Y _8239_/A _8243_/B VPWR VGND sg13g2_nand2_1
XFILLER_121_759 VPWR VGND sg13g2_decap_4
XFILLER_105_288 VPWR VGND sg13g2_decap_8
XFILLER_78_128 VPWR VGND sg13g2_decap_8
XFILLER_120_269 VPWR VGND sg13g2_decap_8
XFILLER_75_802 VPWR VGND sg13g2_fill_2
XFILLER_47_526 VPWR VGND sg13g2_fill_2
XFILLER_47_32 VPWR VGND sg13g2_fill_1
XFILLER_62_518 VPWR VGND sg13g2_decap_4
XFILLER_55_570 VPWR VGND sg13g2_decap_8
XFILLER_15_434 VPWR VGND sg13g2_fill_1
XFILLER_15_456 VPWR VGND sg13g2_fill_2
XFILLER_15_467 VPWR VGND sg13g2_fill_2
XFILLER_42_231 VPWR VGND sg13g2_fill_1
XFILLER_42_253 VPWR VGND sg13g2_decap_8
XFILLER_15_489 VPWR VGND sg13g2_fill_1
XFILLER_30_426 VPWR VGND sg13g2_fill_2
XFILLER_43_798 VPWR VGND sg13g2_fill_2
XFILLER_11_673 VPWR VGND sg13g2_decap_8
XFILLER_11_662 VPWR VGND sg13g2_fill_1
XFILLER_7_633 VPWR VGND sg13g2_decap_8
XFILLER_7_655 VPWR VGND sg13g2_fill_2
XFILLER_7_644 VPWR VGND sg13g2_fill_2
XFILLER_7_677 VPWR VGND sg13g2_decap_4
XFILLER_111_203 VPWR VGND sg13g2_fill_2
XFILLER_112_759 VPWR VGND sg13g2_decap_8
XFILLER_111_225 VPWR VGND sg13g2_fill_2
XFILLER_111_214 VPWR VGND sg13g2_fill_2
XFILLER_88_83 VPWR VGND sg13g2_decap_8
Xclkbuf_leaf_34_clk_i _9183_/CLK clkbuf_3_0__f_clk_i/X VPWR VGND sg13g2_buf_16
XFILLER_38_537 VPWR VGND sg13g2_decap_8
XFILLER_93_665 VPWR VGND sg13g2_fill_1
X_5940_ _5940_/Y _5954_/A _5998_/A _5954_/C _8534_/A VPWR VGND sg13g2_nand4_1
XFILLER_53_507 VPWR VGND sg13g2_decap_8
XFILLER_80_348 VPWR VGND sg13g2_decap_4
X_5871_ _9310_/D _9310_/Q _5920_/B _5870_/Y VPWR VGND sg13g2_a21o_1
X_7610_ _7611_/D _9070_/Q _7670_/B _7608_/X VPWR VGND sg13g2_o21ai_1
XFILLER_33_231 VPWR VGND sg13g2_decap_8
X_4822_ _4847_/B _9339_/Q _9340_/Q VPWR VGND sg13g2_nor2b_1
XFILLER_21_415 VPWR VGND sg13g2_decap_4
X_8590_ _8590_/Q _9708_/CLK _8590_/D fanout948/X VPWR VGND sg13g2_dfrbpq_1
X_9467__2913 _9467_/RESET_B VPWR VGND sg13g2_tiehi
X_7541_ _7541_/Y _9067_/Q _7644_/B _7651_/A VPWR VGND sg13g2_nand3b_1
X_4753_ _4753_/Y _4855_/A _4752_/Y _4772_/A VPWR VGND sg13g2_o21ai_1
X_7472_ _7476_/C _7466_/Y _7471_/Y _7512_/B1 VPWR VGND sg13g2_o21ai_1
X_4684_ _4685_/B _9657_/Q _4687_/A _9659_/Q VPWR VGND sg13g2_a21oi_1
XFILLER_107_509 VPWR VGND sg13g2_decap_8
X_9211_ _9211_/Q _9219_/CLK _9211_/D place2409/X VPWR VGND sg13g2_dfrbpq_1
Xplace2501 place2501/X place2504/X VPWR VGND sg13g2_buf_1
Xplace2512 _6224_/A _6397_/B VPWR VGND sg13g2_buf_1
Xplace2523 _6035_/A _6037_/A VPWR VGND sg13g2_buf_1
X_6423_ _6423_/Y _6512_/A1 _6512_/A2 _6423_/B1 VPWR VGND sg13g2_a21oi_1
Xplace1800 _5288_/A1 _5080_/Y VPWR VGND sg13g2_buf_1
Xplace2534 _7172_/B _7168_/D VPWR VGND sg13g2_buf_1
Xplace1811 _8383_/A _8411_/A VPWR VGND sg13g2_buf_1
XFILLER_108_27 VPWR VGND sg13g2_decap_8
X_9142_ _9142_/Q _9199_/CLK _9142_/D place2427/X VPWR VGND sg13g2_dfrbpq_1
X_6354_ _6354_/Y _6353_/X _6390_/A2 _8867_/Q _6130_/B VPWR VGND sg13g2_a22oi_1
Xplace1833 _8017_/A _8007_/A VPWR VGND sg13g2_buf_1
Xplace1822 _8129_/B _8161_/B VPWR VGND sg13g2_buf_1
Xplace1844 _7917_/A _7953_/A VPWR VGND sg13g2_buf_1
Xplace1855 _6006_/S _5960_/B VPWR VGND sg13g2_buf_1
XFILLER_115_564 VPWR VGND sg13g2_fill_1
Xhold3203 _7577_/A _8913_/Q VPWR VGND sg13g2_dlygate4sd3_1
Xplace1877 _7576_/S _7830_/S VPWR VGND sg13g2_buf_1
X_5305_ _5308_/A _5304_/Y _5315_/B _5306_/C VPWR VGND sg13g2_o21ai_1
Xclkbuf_3_4__f_clk_i clkbuf_leaf_9_clk_i/A clkbuf_0_clk_i/X VPWR VGND sg13g2_buf_8
Xplace1888 _7127_/A2 _7100_/A2 VPWR VGND sg13g2_buf_1
Xhold3214 _4396_/A1 _8673_/Q VPWR VGND sg13g2_dlygate4sd3_1
X_6285_ _6285_/Y _6325_/A1 _6284_/Y _6229_/B VPWR VGND sg13g2_o21ai_1
Xplace1866 _8486_/A _8492_/A VPWR VGND sg13g2_buf_1
X_9073_ _9073_/Q _9501_/CLK _9073_/D place2464/X VPWR VGND sg13g2_dfrbpq_1
X_5236_ _8767_/D _5274_/A1 _5359_/C _5233_/Y _5235_/Y VPWR VGND sg13g2_a22oi_1
X_8024_ _8024_/Y _8024_/A _8052_/B VPWR VGND sg13g2_nand2_1
Xhold3236 _5435_/A1 _8674_/Q VPWR VGND sg13g2_dlygate4sd3_1
Xhold3225 _4391_/A1 _8676_/Q VPWR VGND sg13g2_dlygate4sd3_1
Xplace1899 _6279_/A _6056_/Y VPWR VGND sg13g2_buf_1
Xhold3247 _5634_/A1 _8621_/Q VPWR VGND sg13g2_dlygate4sd3_1
X_5167_ _5167_/Y _5126_/Y _5187_/D _5165_/Y _5138_/Y VPWR VGND sg13g2_a22oi_1
XFILLER_29_526 VPWR VGND sg13g2_decap_8
X_5098_ _5100_/B _5098_/A _5147_/D _5117_/D _5098_/D VPWR VGND sg13g2_nand4_1
XFILLER_84_643 VPWR VGND sg13g2_fill_2
X_8926_ _8926_/Q _9620_/CLK _8926_/D place2429/X VPWR VGND sg13g2_dfrbpq_1
XFILLER_56_378 VPWR VGND sg13g2_decap_8
XFILLER_83_186 VPWR VGND sg13g2_decap_8
XFILLER_71_326 VPWR VGND sg13g2_fill_2
X_8857_ _8857_/Q _9253_/CLK _8857_/D place2488/X VPWR VGND sg13g2_dfrbpq_1
X_7808_ _7810_/C _9273_/Q _8515_/D _7808_/B1 _8812_/Q VPWR VGND sg13g2_a22oi_1
X_8788_ _8788_/Q _9219_/CLK _8788_/D place2403/X VPWR VGND sg13g2_dfrbpq_1
XFILLER_52_573 VPWR VGND sg13g2_fill_1
X_7739_ _7753_/A _9299_/Q _7843_/A2 _7843_/B1 _9331_/Q _7738_/Y VPWR VGND sg13g2_a221oi_1
XFILLER_8_408 VPWR VGND sg13g2_decap_8
X_9409_ _9409_/Q _9409_/CLK _9409_/D place2404/X VPWR VGND sg13g2_dfrbpq_1
XFILLER_20_481 VPWR VGND sg13g2_fill_1
XFILLER_4_614 VPWR VGND sg13g2_decap_8
XFILLER_118_391 VPWR VGND sg13g2_decap_4
XFILLER_3_146 VPWR VGND sg13g2_decap_8
XFILLER_102_781 VPWR VGND sg13g2_decap_4
X_9545__2835 _9545_/RESET_B VPWR VGND sg13g2_tiehi
XFILLER_87_492 VPWR VGND sg13g2_fill_1
XFILLER_90_624 VPWR VGND sg13g2_decap_4
XFILLER_75_676 VPWR VGND sg13g2_decap_8
XFILLER_90_646 VPWR VGND sg13g2_fill_1
XFILLER_15_253 VPWR VGND sg13g2_decap_4
XFILLER_16_765 VPWR VGND sg13g2_fill_1
XFILLER_43_562 VPWR VGND sg13g2_decap_8
XFILLER_16_798 VPWR VGND sg13g2_decap_8
XFILLER_88_7 VPWR VGND sg13g2_fill_2
XFILLER_70_392 VPWR VGND sg13g2_fill_1
XFILLER_15_297 VPWR VGND sg13g2_decap_8
XFILLER_30_234 VPWR VGND sg13g2_fill_1
XFILLER_31_768 VPWR VGND sg13g2_decap_8
XFILLER_31_779 VPWR VGND sg13g2_fill_2
XFILLER_30_289 VPWR VGND sg13g2_decap_8
XFILLER_99_82 VPWR VGND sg13g2_decap_8
XFILLER_98_757 VPWR VGND sg13g2_decap_4
XFILLER_3_680 VPWR VGND sg13g2_decap_8
XFILLER_97_256 VPWR VGND sg13g2_fill_2
X_6070_ _6070_/X _8960_/Q _9022_/Q _9084_/Q _9146_/Q _6061_/A _6349_/S1 VPWR VGND
+ sg13g2_mux4_1
X_5021_ _5129_/D _8517_/B _5177_/A VPWR VGND sg13g2_nor2_1
XFILLER_38_334 VPWR VGND sg13g2_fill_1
XFILLER_38_356 VPWR VGND sg13g2_decap_4
X_8711_ _8711_/Q _9662_/CLK _8711_/D place2445/X VPWR VGND sg13g2_dfrbpq_1
X_6972_ _6972_/Y _7701_/C _7244_/D _6972_/C VPWR VGND sg13g2_nor3_1
X_5923_ _5925_/A _5923_/A1 _5952_/A _5922_/Y VPWR VGND sg13g2_o21ai_1
X_9691_ _9691_/Q _9692_/CLK _9691_/D place2493/X VPWR VGND sg13g2_dfrbpq_1
X_8642_ _8642_/Q _9449_/CLK _8642_/D fanout980/X VPWR VGND sg13g2_dfrbpq_1
X_5854_ _5854_/Y _5848_/Y _5853_/X _5837_/Y VPWR VGND sg13g2_a21oi_1
X_8573_ _8573_/Y _8577_/A _8577_/B _8573_/C VPWR VGND sg13g2_nand3_1
X_4805_ _4807_/B _4923_/A _4795_/B VPWR VGND sg13g2_nor2b_1
X_5785_ _8577_/A _7735_/A _8515_/A _5785_/C _7735_/B VPWR VGND sg13g2_nand4_1
XFILLER_21_256 VPWR VGND sg13g2_decap_4
X_7524_ _7525_/C _7820_/A _9128_/Q _7701_/C VPWR VGND sg13g2_nor3_1
X_4736_ _4736_/Y _6065_/A _4739_/B VPWR VGND sg13g2_nor2b_1
X_4667_ _4667_/Y _9648_/Q _8718_/Q _6953_/S _4661_/Y VPWR VGND sg13g2_a22oi_1
X_7455_ _7455_/Y _9343_/Q _7482_/A _7455_/C VPWR VGND sg13g2_nor3_1
Xplace2331 _4903_/B _8818_/Q VPWR VGND sg13g2_buf_1
Xplace2320 _6262_/A _9246_/Q VPWR VGND sg13g2_buf_1
Xplace2342 _5924_/D _5762_/A1 VPWR VGND sg13g2_buf_1
Xplace2353 _8414_/C _8432_/C VPWR VGND sg13g2_buf_1
X_7386_ _7386_/X _7386_/A _7404_/B _8966_/Q VPWR VGND sg13g2_or3_1
X_6406_ _6406_/Y _6404_/Y _6405_/Y _6044_/C VPWR VGND sg13g2_a21oi_1
Xplace2364 _8411_/C _8391_/C VPWR VGND sg13g2_buf_1
XFILLER_115_361 VPWR VGND sg13g2_decap_8
Xplace2397 place2397/X place2398/X VPWR VGND sg13g2_buf_1
X_4598_ _4606_/C _9674_/Q _4598_/B VPWR VGND sg13g2_nor2_1
X_6337_ _6337_/X _8990_/Q _9052_/Q _9114_/Q _9176_/Q _6061_/A _6349_/S1 VPWR VGND
+ sg13g2_mux4_1
Xplace2386 _6173_/A _6410_/B VPWR VGND sg13g2_buf_1
X_9125_ _9125_/Q _9188_/CLK _9125_/D place2474/X VPWR VGND sg13g2_dfrbpq_1
Xplace2375 _8490_/C _8492_/C VPWR VGND sg13g2_buf_1
Xhold3022 _9636_/D _4491_/Y VPWR VGND sg13g2_dlygate4sd3_1
Xhold3033 _8217_/A _9109_/Q VPWR VGND sg13g2_dlygate4sd3_1
Xhold3011 _6435_/B1 _9395_/Q VPWR VGND sg13g2_dlygate4sd3_1
Xhold3000 _8055_/A _9034_/Q VPWR VGND sg13g2_dlygate4sd3_1
XFILLER_95_29 VPWR VGND sg13g2_decap_4
Xhold3066 _8345_/A _9173_/Q VPWR VGND sg13g2_dlygate4sd3_1
X_9056_ _9056_/Q clkload5/A _9056_/D place2497/X VPWR VGND sg13g2_dfrbpq_1
XFILLER_0_149 VPWR VGND sg13g2_decap_8
X_6268_ _6273_/B _6103_/B _6188_/A _6459_/C _6153_/D _6077_/Y VPWR VGND sg13g2_a221oi_1
Xhold3044 _4576_/A _9696_/Q VPWR VGND sg13g2_dlygate4sd3_1
Xhold3055 _8129_/A _9065_/Q VPWR VGND sg13g2_dlygate4sd3_1
Xhold3099 _6628_/A _9440_/Q VPWR VGND sg13g2_dlygate4sd3_1
XFILLER_103_578 VPWR VGND sg13g2_fill_1
Xhold3088 _6657_/A _9449_/Q VPWR VGND sg13g2_dlygate4sd3_1
XFILLER_88_289 VPWR VGND sg13g2_fill_1
X_5219_ _8764_/D _5269_/A1 _5356_/C _5218_/Y VPWR VGND sg13g2_o21ai_1
Xhold3077 _8143_/A _9072_/Q VPWR VGND sg13g2_dlygate4sd3_1
X_6199_ _6199_/Y _8847_/Q _6962_/D _6422_/B1 _6198_/X VPWR VGND sg13g2_a22oi_1
X_8007_ _8007_/Y _8007_/A _9014_/Q _8411_/C VPWR VGND sg13g2_nand3_1
XFILLER_29_334 VPWR VGND sg13g2_decap_8
XFILLER_56_164 VPWR VGND sg13g2_fill_1
XFILLER_17_507 VPWR VGND sg13g2_decap_8
XFILLER_84_495 VPWR VGND sg13g2_fill_2
XFILLER_84_484 VPWR VGND sg13g2_fill_1
XFILLER_44_315 VPWR VGND sg13g2_fill_2
X_8909_ _8909_/Q _9611_/CLK _8909_/D place2414/X VPWR VGND sg13g2_dfrbpq_1
X_9889_ _9889_/X _9889_/A VPWR VGND sg13g2_buf_1
XFILLER_72_679 VPWR VGND sg13g2_decap_4
XFILLER_25_540 VPWR VGND sg13g2_decap_8
XFILLER_40_510 VPWR VGND sg13g2_decap_4
XFILLER_60_54 VPWR VGND sg13g2_decap_8
XFILLER_8_238 VPWR VGND sg13g2_fill_2
XFILLER_60_98 VPWR VGND sg13g2_decap_8
XFILLER_114_0 VPWR VGND sg13g2_decap_8
XFILLER_4_411 VPWR VGND sg13g2_decap_8
XFILLER_5_49 VPWR VGND sg13g2_decap_8
XFILLER_121_320 VPWR VGND sg13g2_fill_1
XFILLER_69_74 VPWR VGND sg13g2_decap_4
XFILLER_121_342 VPWR VGND sg13g2_fill_1
XFILLER_121_331 VPWR VGND sg13g2_decap_8
XFILLER_121_397 VPWR VGND sg13g2_decap_8
XFILLER_75_440 VPWR VGND sg13g2_decap_4
XFILLER_48_632 VPWR VGND sg13g2_decap_8
XFILLER_63_602 VPWR VGND sg13g2_decap_8
XFILLER_75_495 VPWR VGND sg13g2_decap_8
XFILLER_62_123 VPWR VGND sg13g2_fill_1
XFILLER_47_186 VPWR VGND sg13g2_fill_1
XFILLER_47_197 VPWR VGND sg13g2_decap_8
XFILLER_63_657 VPWR VGND sg13g2_decap_8
XFILLER_50_329 VPWR VGND sg13g2_decap_8
XFILLER_31_554 VPWR VGND sg13g2_fill_1
X_5570_ _5570_/Y _6638_/A _5570_/B VPWR VGND sg13g2_nand2_1
XFILLER_31_598 VPWR VGND sg13g2_fill_2
X_4521_ _4521_/Y _7482_/A _9343_/Q VPWR VGND sg13g2_nor2b_1
XFILLER_116_136 VPWR VGND sg13g2_decap_8
X_7240_ _7240_/Y _8895_/Q _7812_/S VPWR VGND sg13g2_nor2_1
XFILLER_7_282 VPWR VGND sg13g2_decap_8
X_4452_ _5392_/C _6064_/A _4452_/B _6033_/C _6047_/A VPWR VGND sg13g2_and4_1
X_4383_ _5416_/B _9623_/Q _9624_/Q _9626_/Q _9625_/Q VPWR VGND sg13g2_nor4_1
X_7171_ _8875_/D _7170_/Y _8875_/Q _7185_/S VPWR VGND sg13g2_mux2_1
XFILLER_98_543 VPWR VGND sg13g2_decap_4
X_6122_ _6132_/A _6379_/A1 _6346_/B _6122_/B1 VPWR VGND sg13g2_a21oi_1
XFILLER_98_587 VPWR VGND sg13g2_fill_1
X_6053_ _6371_/B _6275_/B _6053_/B VPWR VGND sg13g2_and2_1
XFILLER_85_248 VPWR VGND sg13g2_decap_8
XFILLER_38_120 VPWR VGND sg13g2_decap_4
XFILLER_39_654 VPWR VGND sg13g2_fill_1
X_5004_ _5005_/B _4810_/Y _5010_/B _4821_/Y VPWR VGND sg13g2_a21oi_1
XFILLER_66_451 VPWR VGND sg13g2_fill_2
XFILLER_54_602 VPWR VGND sg13g2_fill_2
XFILLER_38_164 VPWR VGND sg13g2_fill_1
XFILLER_94_793 VPWR VGND sg13g2_fill_2
XFILLER_81_410 VPWR VGND sg13g2_fill_2
XFILLER_38_186 VPWR VGND sg13g2_decap_8
XFILLER_121_49 VPWR VGND sg13g2_decap_8
X_6955_ _9208_/D _9675_/Q _9208_/Q _6955_/S VPWR VGND sg13g2_mux2_1
XFILLER_81_465 VPWR VGND sg13g2_fill_1
XFILLER_81_454 VPWR VGND sg13g2_decap_4
XFILLER_54_657 VPWR VGND sg13g2_decap_8
XFILLER_53_145 VPWR VGND sg13g2_decap_4
X_5906_ _5906_/Y _5932_/D _5906_/A2 _5905_/Y VPWR VGND sg13g2_a21oi_1
X_9674_ _9674_/Q _9675_/CLK _9674_/D place2443/X VPWR VGND sg13g2_dfrbpq_1
XFILLER_53_167 VPWR VGND sg13g2_decap_4
X_6886_ _9609_/D _6885_/X _9609_/Q _6910_/S VPWR VGND sg13g2_mux2_1
X_8625_ _8625_/Q _9587_/CLK _8625_/D fanout968/X VPWR VGND sg13g2_dfrbpq_1
XFILLER_22_532 VPWR VGND sg13g2_decap_8
X_5837_ _5837_/Y _8517_/C _5837_/A2 _5836_/Y VPWR VGND sg13g2_a21oi_1
XFILLER_22_565 VPWR VGND sg13g2_decap_8
X_8556_ _8557_/A _9271_/Q _8560_/A2 _8560_/B1 _9497_/Q VPWR VGND sg13g2_a22oi_1
X_5768_ _5768_/Y _5772_/A1 _5766_/Y _5767_/Y VPWR VGND sg13g2_a21oi_1
XFILLER_22_598 VPWR VGND sg13g2_fill_1
X_4719_ _9689_/D _6956_/S _4723_/A _4718_/Y VPWR VGND sg13g2_o21ai_1
X_7507_ _7511_/B _9034_/Q _7816_/B VPWR VGND sg13g2_nor2_1
X_8487_ _9248_/D _8486_/A _8487_/A2 _8486_/Y VPWR VGND sg13g2_o21ai_1
XFILLER_108_648 VPWR VGND sg13g2_decap_4
X_7438_ _7438_/Y _7433_/Y _7437_/Y _4541_/Y VPWR VGND sg13g2_o21ai_1
X_5699_ _5700_/A _5423_/B _5699_/A2 _5699_/B1 _5699_/B2 VPWR VGND sg13g2_a22oi_1
Xplace2172 _4782_/D _4880_/D VPWR VGND sg13g2_buf_1
Xplace2161 _7670_/B _7815_/B VPWR VGND sg13g2_buf_1
Xplace2150 _4972_/B _4979_/A2 VPWR VGND sg13g2_buf_1
Xplace2194 _5585_/A _5597_/A VPWR VGND sg13g2_buf_1
Xplace2183 _7747_/C _7723_/C VPWR VGND sg13g2_buf_1
X_7369_ _7369_/Y _9058_/Q _7404_/B _7369_/C VPWR VGND sg13g2_nand3b_1
XFILLER_103_331 VPWR VGND sg13g2_fill_2
X_9108_ _9108_/Q _9198_/CLK _9108_/D place2437/X VPWR VGND sg13g2_dfrbpq_1
XFILLER_39_33 VPWR VGND sg13g2_fill_1
XFILLER_103_364 VPWR VGND sg13g2_fill_1
X_9039_ _9039_/Q clkload6/A _9039_/D place2434/X VPWR VGND sg13g2_dfrbpq_1
XFILLER_57_462 VPWR VGND sg13g2_fill_1
XFILLER_72_421 VPWR VGND sg13g2_decap_4
XFILLER_44_101 VPWR VGND sg13g2_fill_2
XFILLER_45_646 VPWR VGND sg13g2_decap_8
XFILLER_60_605 VPWR VGND sg13g2_decap_8
XFILLER_60_638 VPWR VGND sg13g2_decap_4
XFILLER_55_98 VPWR VGND sg13g2_fill_2
XFILLER_32_329 VPWR VGND sg13g2_fill_1
X_9495__2885 _9495_/RESET_B VPWR VGND sg13g2_tiehi
XFILLER_9_558 VPWR VGND sg13g2_decap_4
XFILLER_40_395 VPWR VGND sg13g2_decap_8
XFILLER_114_629 VPWR VGND sg13g2_fill_1
XFILLER_113_106 VPWR VGND sg13g2_fill_1
XFILLER_5_786 VPWR VGND sg13g2_fill_1
XFILLER_96_50 VPWR VGND sg13g2_decap_8
XFILLER_95_524 VPWR VGND sg13g2_fill_1
XFILLER_68_716 VPWR VGND sg13g2_fill_1
XFILLER_95_557 VPWR VGND sg13g2_decap_8
XFILLER_0_491 VPWR VGND sg13g2_decap_8
XFILLER_67_259 VPWR VGND sg13g2_decap_8
XFILLER_82_229 VPWR VGND sg13g2_decap_8
XFILLER_35_101 VPWR VGND sg13g2_fill_2
X_6740_ _6741_/B _9638_/Q _6742_/D _9459_/Q VPWR VGND sg13g2_o21ai_1
XFILLER_51_638 VPWR VGND sg13g2_decap_8
XFILLER_35_178 VPWR VGND sg13g2_decap_8
XFILLER_51_649 VPWR VGND sg13g2_fill_1
X_6671_ _6671_/Y _6671_/A _6671_/B VPWR VGND sg13g2_nand2_1
X_9390_ _9390_/Q _9406_/CLK _9390_/D place2491/X VPWR VGND sg13g2_dfrbpq_1
X_8410_ _9205_/D _5373_/C _8411_/A _8409_/Y VPWR VGND sg13g2_o21ai_1
X_5622_ _5622_/Y _5423_/B _5498_/X _5500_/Y _8662_/Q VPWR VGND sg13g2_a22oi_1
X_5553_ _5553_/Y _8640_/Q _5592_/A2 _5586_/B1 _8639_/Q VPWR VGND sg13g2_a22oi_1
X_8341_ _8341_/Y _8341_/A _8343_/B VPWR VGND sg13g2_nand2_1
XFILLER_77_0 VPWR VGND sg13g2_decap_8
X_4504_ _6982_/A _4504_/A _4504_/B _4504_/C VPWR VGND sg13g2_or3_1
XFILLER_105_607 VPWR VGND sg13g2_decap_4
X_8272_ _9136_/D _8288_/A1 _8080_/Y _8271_/Y VPWR VGND sg13g2_o21ai_1
X_5484_ _5484_/Y _6945_/A _6951_/A VPWR VGND sg13g2_nand2_1
X_9540__2840 _9540_/RESET_B VPWR VGND sg13g2_tiehi
X_7223_ _8890_/D _7222_/Y _8890_/Q _7239_/S VPWR VGND sg13g2_mux2_1
X_4435_ _4437_/A _4435_/A _4435_/B _4435_/C _4435_/D VPWR VGND sg13g2_nor4_1
XFILLER_116_16 VPWR VGND sg13g2_decap_8
XFILLER_113_651 VPWR VGND sg13g2_fill_1
XFILLER_113_640 VPWR VGND sg13g2_decap_8
X_4366_ _4366_/Y _8728_/Q _4366_/B VPWR VGND sg13g2_nand2b_1
X_7154_ _8870_/D _6975_/X _7152_/Y _7153_/Y VPWR VGND sg13g2_o21ai_1
XFILLER_86_524 VPWR VGND sg13g2_fill_1
X_6105_ _6105_/Y _6408_/B _6104_/Y _6103_/Y VPWR VGND sg13g2_o21ai_1
XFILLER_58_237 VPWR VGND sg13g2_decap_8
X_4297_ _6033_/D _6064_/A VPWR VGND sg13g2_inv_1
X_7085_ _8848_/D _7084_/Y _8848_/Q _7085_/S VPWR VGND sg13g2_mux2_1
XFILLER_100_356 VPWR VGND sg13g2_decap_8
XFILLER_86_579 VPWR VGND sg13g2_fill_2
XFILLER_74_708 VPWR VGND sg13g2_fill_2
XFILLER_67_771 VPWR VGND sg13g2_decap_8
X_6036_ _6171_/C _6397_/B _6037_/C VPWR VGND sg13g2_nand2_1
XFILLER_26_101 VPWR VGND sg13g2_decap_4
XFILLER_15_808 VPWR VGND sg13g2_fill_1
XFILLER_27_657 VPWR VGND sg13g2_decap_8
XFILLER_82_785 VPWR VGND sg13g2_fill_1
XFILLER_26_189 VPWR VGND sg13g2_decap_4
X_7987_ _7987_/Y _8019_/A _9004_/Q _8383_/C VPWR VGND sg13g2_nand3_1
X_6938_ _9631_/D _9632_/Q _6931_/Y _6937_/X VPWR VGND sg13g2_a21o_1
X_9657_ _9657_/Q _9662_/CLK _9657_/D place2448/X VPWR VGND sg13g2_dfrbpq_1
X_6869_ _6869_/X _8908_/Q _8940_/Q _6909_/S VPWR VGND sg13g2_mux2_1
X_9588_ _9588_/Q _9588_/CLK _9588_/D _9588_/RESET_B VPWR VGND sg13g2_dfrbpq_1
XFILLER_50_682 VPWR VGND sg13g2_fill_1
XFILLER_10_535 VPWR VGND sg13g2_decap_8
X_8608_ _8608_/Q _9701_/CLK _8608_/D fanout949/X VPWR VGND sg13g2_dfrbpq_1
XFILLER_41_12 VPWR VGND sg13g2_fill_1
XFILLER_108_401 VPWR VGND sg13g2_decap_8
X_8539_ _8540_/B _5124_/A _5024_/Y _9860_/A _8520_/C VPWR VGND sg13g2_a22oi_1
XFILLER_110_109 VPWR VGND sg13g2_fill_1
XFILLER_104_695 VPWR VGND sg13g2_fill_1
XFILLER_89_384 VPWR VGND sg13g2_decap_8
XFILLER_2_28 VPWR VGND sg13g2_decap_8
XFILLER_92_516 VPWR VGND sg13g2_decap_8
XFILLER_92_538 VPWR VGND sg13g2_decap_8
XFILLER_18_657 VPWR VGND sg13g2_decap_8
XFILLER_82_30 VPWR VGND sg13g2_fill_2
XFILLER_60_402 VPWR VGND sg13g2_fill_2
X_9590__2800 _9590_/RESET_B VPWR VGND sg13g2_tiehi
XFILLER_60_435 VPWR VGND sg13g2_decap_8
XFILLER_17_189 VPWR VGND sg13g2_fill_1
XFILLER_70_7 VPWR VGND sg13g2_decap_8
XFILLER_114_448 VPWR VGND sg13g2_fill_1
XFILLER_96_800 VPWR VGND sg13g2_fill_1
XFILLER_68_557 VPWR VGND sg13g2_decap_8
XFILLER_110_676 VPWR VGND sg13g2_fill_1
X_8890_ _8890_/Q _9253_/CLK _8890_/D place2459/X VPWR VGND sg13g2_dfrbpq_1
X_7910_ _8968_/D _5353_/C _7917_/A _7908_/Y VPWR VGND sg13g2_o21ai_1
XFILLER_64_752 VPWR VGND sg13g2_fill_1
X_7841_ _7841_/Y _9466_/Q _7841_/B _7841_/C _7841_/D VPWR VGND sg13g2_nor4_1
XFILLER_64_774 VPWR VGND sg13g2_decap_8
XFILLER_24_616 VPWR VGND sg13g2_decap_8
X_7772_ _7773_/D _7772_/A _7772_/B _7772_/C _7772_/D VPWR VGND sg13g2_and4_1
XFILLER_51_424 VPWR VGND sg13g2_fill_1
X_4984_ _4984_/Y _4981_/Y _4983_/Y _4957_/D VPWR VGND sg13g2_a21oi_1
X_6723_ _9491_/D _9532_/Q _9491_/Q _6726_/S VPWR VGND sg13g2_mux2_1
XFILLER_20_800 VPWR VGND sg13g2_fill_1
X_9511_ _9511_/Q _9511_/CLK _9511_/D _9511_/RESET_B VPWR VGND sg13g2_dfrbpq_1
X_9442_ _9442_/Q _9582_/CLK _9442_/D fanout983/X VPWR VGND sg13g2_dfrbpq_1
X_6654_ _6654_/Y _6654_/A _6654_/B VPWR VGND sg13g2_nand2_1
X_5605_ _8656_/D _5604_/Y _5603_/Y _5623_/B1 VPWR VGND sg13g2_a21oi_1
XFILLER_118_743 VPWR VGND sg13g2_fill_2
X_6585_ _6585_/Y _6588_/C _8629_/Q _9561_/Q _6566_/Y VPWR VGND sg13g2_a22oi_1
X_9373_ _9373_/Q _9407_/CLK _9373_/D place2490/X VPWR VGND sg13g2_dfrbpq_1
X_5536_ _8633_/D _5535_/Y _5534_/Y _5593_/B1 VPWR VGND sg13g2_a21oi_1
X_8324_ _9162_/D _8346_/A1 _7928_/Y _8323_/Y VPWR VGND sg13g2_o21ai_1
XFILLER_11_37 VPWR VGND sg13g2_decap_8
X_9599__2791 _9599_/RESET_B VPWR VGND sg13g2_tiehi
Xoutput2740 slave_rdata_o[17] _4921_/Y VPWR VGND sg13g2_buf_1
X_5467_ _5468_/A _5469_/A1 _8692_/Q _8693_/Q _5467_/B2 VPWR VGND sg13g2_a22oi_1
X_8255_ _8255_/Y _8255_/A _8285_/B VPWR VGND sg13g2_nand2_1
X_4418_ _6451_/D _4425_/B _4425_/C VPWR VGND sg13g2_nand2_1
Xoutput2762 slave_rdata_o[8] _4851_/Y VPWR VGND sg13g2_buf_1
X_7206_ _8885_/D _7205_/Y _8885_/Q _7213_/S VPWR VGND sg13g2_mux2_1
Xoutput2751 slave_rdata_o[27] _4993_/Y VPWR VGND sg13g2_buf_1
X_5398_ _5412_/C _7245_/A _7245_/C _7244_/C _5398_/D VPWR VGND sg13g2_nor4_1
X_8186_ _9093_/D _8190_/A1 _8047_/Y _8185_/Y VPWR VGND sg13g2_o21ai_1
X_4349_ _4506_/B _9462_/Q _9461_/Q _4675_/A VPWR VGND sg13g2_o21ai_1
XFILLER_101_632 VPWR VGND sg13g2_decap_8
X_7137_ _7137_/Y _7889_/D _6977_/Y _7132_/Y _4436_/A VPWR VGND sg13g2_a22oi_1
XFILLER_59_579 VPWR VGND sg13g2_fill_2
X_7068_ _7068_/Y _7165_/A _7172_/B _7080_/C VPWR VGND sg13g2_nand3_1
XFILLER_101_698 VPWR VGND sg13g2_decap_8
XFILLER_86_387 VPWR VGND sg13g2_decap_8
X_6019_ _6019_/Y _6019_/A _9690_/Q _6064_/D VPWR VGND sg13g2_nor3_1
XFILLER_27_443 VPWR VGND sg13g2_decap_8
XFILLER_82_571 VPWR VGND sg13g2_decap_4
XFILLER_54_262 VPWR VGND sg13g2_decap_8
XFILLER_15_605 VPWR VGND sg13g2_fill_2
XFILLER_70_755 VPWR VGND sg13g2_fill_1
XFILLER_54_273 VPWR VGND sg13g2_fill_2
XFILLER_15_649 VPWR VGND sg13g2_decap_8
XFILLER_27_498 VPWR VGND sg13g2_decap_4
XFILLER_36_89 VPWR VGND sg13g2_decap_4
XFILLER_42_424 VPWR VGND sg13g2_decap_8
XFILLER_42_457 VPWR VGND sg13g2_decap_8
XFILLER_50_490 VPWR VGND sg13g2_decap_4
XFILLER_22_181 VPWR VGND sg13g2_fill_2
XFILLER_109_721 VPWR VGND sg13g2_decap_8
XFILLER_6_347 VPWR VGND sg13g2_fill_2
XFILLER_123_201 VPWR VGND sg13g2_decap_4
XFILLER_108_264 VPWR VGND sg13g2_decap_8
XFILLER_7_0 VPWR VGND sg13g2_decap_8
XFILLER_2_531 VPWR VGND sg13g2_fill_2
XFILLER_77_30 VPWR VGND sg13g2_decap_8
XFILLER_2_564 VPWR VGND sg13g2_fill_2
XFILLER_104_492 VPWR VGND sg13g2_decap_8
XFILLER_89_192 VPWR VGND sg13g2_decap_8
XFILLER_93_803 VPWR VGND sg13g2_fill_2
XFILLER_37_207 VPWR VGND sg13g2_fill_2
XFILLER_46_741 VPWR VGND sg13g2_decap_8
XFILLER_61_722 VPWR VGND sg13g2_decap_4
XFILLER_18_498 VPWR VGND sg13g2_decap_8
XFILLER_45_273 VPWR VGND sg13g2_fill_2
XFILLER_60_232 VPWR VGND sg13g2_fill_2
XFILLER_14_693 VPWR VGND sg13g2_decap_8
X_6370_ _6371_/C _6176_/A _6369_/Y _6367_/Y VPWR VGND sg13g2_a21oi_1
XFILLER_115_724 VPWR VGND sg13g2_fill_2
X_5321_ _5322_/B _5334_/A _5334_/B _9886_/A VPWR VGND sg13g2_nand3_1
XFILLER_54_2 VPWR VGND sg13g2_fill_1
XFILLER_5_380 VPWR VGND sg13g2_fill_2
X_8040_ _9028_/D _8100_/A1 _8039_/Y _8038_/Y VPWR VGND sg13g2_o21ai_1
XFILLER_88_619 VPWR VGND sg13g2_fill_2
X_5252_ _5362_/C _8432_/C _9489_/Q VPWR VGND sg13g2_nand2_1
XFILLER_87_129 VPWR VGND sg13g2_fill_2
X_5183_ _8759_/D _5080_/Y _5351_/C _5181_/Y _5182_/Y VPWR VGND sg13g2_a22oi_1
XFILLER_3_60 VPWR VGND sg13g2_fill_1
X_9490__2890 _9490_/RESET_B VPWR VGND sg13g2_tiehi
X_8942_ _8942_/Q _9603_/CLK _8942_/D place2431/X VPWR VGND sg13g2_dfrbpq_1
XFILLER_37_741 VPWR VGND sg13g2_decap_8
XFILLER_37_752 VPWR VGND sg13g2_fill_2
X_8873_ _8873_/Q _9242_/CLK _8873_/D place2492/X VPWR VGND sg13g2_dfrbpq_1
X_7824_ _7827_/D _8813_/Q _7824_/B VPWR VGND sg13g2_nand2_1
XFILLER_52_744 VPWR VGND sg13g2_decap_8
X_7755_ _8921_/D _8921_/Q _7754_/Y _7774_/S VPWR VGND sg13g2_mux2_1
Xinput2605 _5875_/B1 master_rdata_i[5] VPWR VGND sg13g2_buf_1
XFILLER_51_265 VPWR VGND sg13g2_fill_2
Xinput2616 _6064_/A slave_addr_i[8] VPWR VGND sg13g2_buf_1
X_4967_ _4967_/Y _4915_/Y _4965_/Y _4966_/Y VPWR VGND sg13g2_o21ai_1
X_7686_ _7687_/D _9043_/Q _7719_/B _7685_/X VPWR VGND sg13g2_o21ai_1
X_6706_ _9474_/D _9515_/Q _9474_/Q _6733_/S VPWR VGND sg13g2_mux2_1
XFILLER_20_652 VPWR VGND sg13g2_decap_8
Xinput2649 _4435_/B slave_wdata_i[4] VPWR VGND sg13g2_buf_1
Xinput2627 _7175_/B slave_wdata_i[13] VPWR VGND sg13g2_buf_1
Xinput2638 _7210_/B slave_wdata_i[23] VPWR VGND sg13g2_buf_1
X_4898_ _5012_/C _4999_/B _4928_/B _4898_/C VPWR VGND sg13g2_nand3b_1
X_6637_ _9442_/D _6653_/A1 _6636_/Y _6634_/Y VPWR VGND sg13g2_o21ai_1
X_9425_ _9425_/Q _9587_/CLK _9425_/D fanout978/X VPWR VGND sg13g2_dfrbpq_1
XFILLER_20_663 VPWR VGND sg13g2_decap_8
XFILLER_118_7 VPWR VGND sg13g2_decap_8
X_6568_ _6568_/Y _8624_/Q _5478_/Y _6567_/X VPWR VGND sg13g2_o21ai_1
X_9356_ _9356_/Q clkload9/A _9356_/D place2505/X VPWR VGND sg13g2_dfrbpq_1
X_5519_ _5519_/Y _5525_/A _5525_/B _8629_/Q _5525_/D VPWR VGND sg13g2_nand4_1
X_8307_ _8307_/Y _8307_/A _8347_/B VPWR VGND sg13g2_nand2_1
X_9287_ _9287_/Q _9305_/CLK _9287_/D place2395/X VPWR VGND sg13g2_dfrbpq_1
XFILLER_106_768 VPWR VGND sg13g2_fill_1
X_6499_ _6499_/Y _9019_/Q _6506_/A2 _6507_/A2 _9205_/Q VPWR VGND sg13g2_a22oi_1
Xclkbuf_leaf_0_clk_i _9501_/CLK clkload0/A VPWR VGND sg13g2_buf_16
X_8238_ _9119_/D _8252_/A1 _8034_/Y _8237_/Y VPWR VGND sg13g2_o21ai_1
XFILLER_0_7 VPWR VGND sg13g2_decap_8
X_8169_ _8169_/Y _8169_/A _8191_/B VPWR VGND sg13g2_nand2_1
XFILLER_120_248 VPWR VGND sg13g2_decap_8
XFILLER_86_173 VPWR VGND sg13g2_decap_4
XFILLER_74_346 VPWR VGND sg13g2_fill_1
XFILLER_74_335 VPWR VGND sg13g2_decap_8
XFILLER_103_83 VPWR VGND sg13g2_decap_8
XFILLER_70_530 VPWR VGND sg13g2_decap_8
XFILLER_15_413 VPWR VGND sg13g2_decap_8
XFILLER_43_722 VPWR VGND sg13g2_fill_1
XFILLER_42_243 VPWR VGND sg13g2_fill_1
XFILLER_70_596 VPWR VGND sg13g2_decap_8
XFILLER_63_87 VPWR VGND sg13g2_fill_2
XFILLER_8_49 VPWR VGND sg13g2_decap_4
XFILLER_42_298 VPWR VGND sg13g2_decap_8
XFILLER_11_696 VPWR VGND sg13g2_fill_1
XFILLER_6_122 VPWR VGND sg13g2_decap_4
XFILLER_78_685 VPWR VGND sg13g2_fill_1
XFILLER_92_132 VPWR VGND sg13g2_fill_1
XFILLER_19_752 VPWR VGND sg13g2_decap_8
XFILLER_19_774 VPWR VGND sg13g2_decap_8
XFILLER_19_785 VPWR VGND sg13g2_fill_1
X_5870_ _5870_/Y _5864_/Y _5869_/X _5837_/Y VPWR VGND sg13g2_a21oi_1
X_4821_ _4821_/Y _4783_/C _4833_/A _4983_/A VPWR VGND sg13g2_o21ai_1
XFILLER_21_405 VPWR VGND sg13g2_decap_4
XFILLER_34_788 VPWR VGND sg13g2_fill_1
X_7540_ _7543_/C _7651_/A _9005_/Q _7650_/C VPWR VGND sg13g2_nor3_1
X_4752_ _4752_/Y _9344_/Q _8817_/Q _4751_/Y VPWR VGND sg13g2_o21ai_1
XFILLER_14_490 VPWR VGND sg13g2_decap_4
XFILLER_33_298 VPWR VGND sg13g2_decap_8
X_4683_ _4683_/Y _8719_/Q _9657_/Q VPWR VGND sg13g2_nor2b_1
X_7471_ _7471_/Y _7822_/A _7471_/B _7471_/C _7471_/D VPWR VGND sg13g2_nor4_1
X_9210_ _9210_/Q _9645_/CLK _9210_/D fanout973/X VPWR VGND sg13g2_dfrbpq_1
Xplace2502 place2502/X place2503/X VPWR VGND sg13g2_buf_1
Xplace2513 _6397_/B _6035_/A VPWR VGND sg13g2_buf_1
X_6422_ _6422_/Y _8880_/Q _6962_/D _6422_/B1 _6421_/X _6398_/Y VPWR VGND sg13g2_a221oi_1
Xplace1801 _5274_/B2 _5269_/A1 VPWR VGND sg13g2_buf_1
X_9141_ _9141_/Q clkload6/A _9141_/D place2436/X VPWR VGND sg13g2_dfrbpq_1
Xplace2524 _6399_/A _6158_/A VPWR VGND sg13g2_buf_1
Xplace2535 _7182_/D _7168_/D VPWR VGND sg13g2_buf_1
Xplace1812 _8411_/A _8409_/A VPWR VGND sg13g2_buf_1
XFILLER_115_543 VPWR VGND sg13g2_decap_8
Xplace1823 _8161_/B _8157_/B VPWR VGND sg13g2_buf_1
Xplace1845 _7899_/A _7953_/A VPWR VGND sg13g2_buf_1
X_6353_ _6353_/X _8993_/Q _9055_/Q _9117_/Q _9179_/Q _6377_/S0 _6381_/S1 VPWR VGND
+ sg13g2_mux4_1
Xplace1834 _8019_/A _8007_/A VPWR VGND sg13g2_buf_1
XFILLER_115_576 VPWR VGND sg13g2_decap_8
Xplace1856 _5920_/B _5960_/B VPWR VGND sg13g2_buf_1
Xhold3215 _7398_/A _8904_/Q VPWR VGND sg13g2_dlygate4sd3_1
X_5304_ _5304_/Y _9882_/A _9883_/A _5329_/B VPWR VGND sg13g2_nand3_1
Xplace1878 _7848_/S _7830_/S VPWR VGND sg13g2_buf_1
Xhold3204 _6574_/A _9424_/Q VPWR VGND sg13g2_dlygate4sd3_1
X_9072_ _9072_/Q clkload7/A _9072_/D place2457/X VPWR VGND sg13g2_dfrbpq_1
X_6284_ _6284_/Y _6271_/A _6438_/D _6283_/Y _6451_/A _6273_/A VPWR VGND sg13g2_a221oi_1
Xplace1867 _8476_/A _8490_/A VPWR VGND sg13g2_buf_1
XFILLER_115_587 VPWR VGND sg13g2_fill_1
XFILLER_102_215 VPWR VGND sg13g2_decap_4
X_5235_ _5235_/Y _5235_/A _5235_/B VPWR VGND sg13g2_nor2_1
X_8023_ _9021_/D _8054_/A1 _8022_/Y _8021_/Y VPWR VGND sg13g2_o21ai_1
Xhold3248 _5685_/A1 _8597_/Q VPWR VGND sg13g2_dlygate4sd3_1
Xhold3237 _8038_/A _9028_/Q VPWR VGND sg13g2_dlygate4sd3_1
Xplace1889 _7100_/A2 _6967_/Y VPWR VGND sg13g2_buf_1
Xhold3226 _8197_/A _9099_/Q VPWR VGND sg13g2_dlygate4sd3_1
XFILLER_69_652 VPWR VGND sg13g2_fill_2
XFILLER_69_641 VPWR VGND sg13g2_fill_1
XFILLER_84_622 VPWR VGND sg13g2_decap_8
X_5166_ _5166_/Y _5166_/A _5166_/B _5192_/B VPWR VGND sg13g2_nand3_1
XFILLER_68_162 VPWR VGND sg13g2_fill_2
XFILLER_96_493 VPWR VGND sg13g2_decap_8
X_5097_ _5101_/B _5132_/A _5132_/B _9259_/Q _5124_/B VPWR VGND sg13g2_nor4_1
XFILLER_68_184 VPWR VGND sg13g2_decap_4
X_8925_ _8925_/Q _9504_/CLK _8925_/D place2428/X VPWR VGND sg13g2_dfrbpq_1
XFILLER_84_699 VPWR VGND sg13g2_decap_8
XFILLER_83_165 VPWR VGND sg13g2_decap_8
XFILLER_56_357 VPWR VGND sg13g2_decap_8
XFILLER_44_508 VPWR VGND sg13g2_decap_8
XFILLER_25_722 VPWR VGND sg13g2_decap_8
X_8856_ _8856_/Q _9407_/CLK _8856_/D place2460/X VPWR VGND sg13g2_dfrbpq_1
XFILLER_52_552 VPWR VGND sg13g2_fill_2
X_5999_ _5999_/Y _5123_/A _5373_/C _5998_/Y VPWR VGND sg13g2_o21ai_1
X_7807_ _7810_/B _7801_/Y _7806_/Y _8083_/D VPWR VGND sg13g2_o21ai_1
X_8787_ _8787_/Q _9253_/CLK _8787_/D place2456/X VPWR VGND sg13g2_dfrbpq_1
XFILLER_52_585 VPWR VGND sg13g2_decap_8
XFILLER_12_427 VPWR VGND sg13g2_decap_8
X_7738_ _7738_/Y _7738_/A VPWR VGND sg13g2_inv_1
X_9408_ _9408_/Q _9409_/CLK _9408_/D place2404/X VPWR VGND sg13g2_dfrbpq_1
X_7669_ _7672_/A _7839_/C _9135_/Q _7723_/C VPWR VGND sg13g2_nor3_1
XFILLER_4_604 VPWR VGND sg13g2_decap_4
XFILLER_106_543 VPWR VGND sg13g2_decap_4
X_9339_ _9339_/Q _9414_/CLK _9339_/D place2501/X VPWR VGND sg13g2_dfrbpq_1
XFILLER_3_125 VPWR VGND sg13g2_decap_8
XFILLER_79_405 VPWR VGND sg13g2_decap_8
XFILLER_58_21 VPWR VGND sg13g2_decap_4
XFILLER_94_408 VPWR VGND sg13g2_fill_1
XFILLER_87_482 VPWR VGND sg13g2_fill_2
XFILLER_75_633 VPWR VGND sg13g2_decap_8
XFILLER_74_132 VPWR VGND sg13g2_decap_8
XFILLER_59_195 VPWR VGND sg13g2_fill_2
XFILLER_47_346 VPWR VGND sg13g2_fill_1
XFILLER_74_165 VPWR VGND sg13g2_fill_2
XFILLER_74_42 VPWR VGND sg13g2_decap_8
XFILLER_62_305 VPWR VGND sg13g2_fill_2
XFILLER_47_368 VPWR VGND sg13g2_fill_1
XFILLER_28_560 VPWR VGND sg13g2_decap_4
XFILLER_74_86 VPWR VGND sg13g2_decap_8
XFILLER_15_210 VPWR VGND sg13g2_fill_2
XFILLER_16_733 VPWR VGND sg13g2_fill_2
XFILLER_16_777 VPWR VGND sg13g2_decap_8
XFILLER_15_265 VPWR VGND sg13g2_fill_1
XFILLER_15_276 VPWR VGND sg13g2_decap_8
XFILLER_30_246 VPWR VGND sg13g2_fill_2
XFILLER_11_493 VPWR VGND sg13g2_decap_8
XFILLER_116_329 VPWR VGND sg13g2_decap_8
XFILLER_99_61 VPWR VGND sg13g2_decap_8
XFILLER_98_736 VPWR VGND sg13g2_decap_4
XFILLER_97_224 VPWR VGND sg13g2_fill_1
X_5020_ _5020_/Y _5020_/A _5020_/B VPWR VGND sg13g2_nand2_1
XFILLER_112_579 VPWR VGND sg13g2_decap_4
XFILLER_66_655 VPWR VGND sg13g2_fill_1
XFILLER_38_379 VPWR VGND sg13g2_decap_4
X_8710_ _8711_/D _9449_/CLK _8710_/D fanout974/X VPWR VGND sg13g2_dfrbpq_1
X_6971_ _8821_/D _6970_/Y _8821_/Q _7131_/S VPWR VGND sg13g2_mux2_1
XFILLER_53_316 VPWR VGND sg13g2_fill_1
XFILLER_19_582 VPWR VGND sg13g2_decap_8
X_5922_ _5922_/Y _5930_/A1 _5930_/A2 _5921_/Y VPWR VGND sg13g2_a21oi_1
XFILLER_0_94 VPWR VGND sg13g2_decap_8
X_9690_ _9690_/Q clkload9/A _9690_/D place2492/X VPWR VGND sg13g2_dfrbpq_1
XFILLER_34_541 VPWR VGND sg13g2_fill_2
X_8641_ _8641_/Q _9449_/CLK _8641_/D fanout980/X VPWR VGND sg13g2_dfrbpq_1
X_5853_ _5853_/X _5850_/Y _5851_/Y _5852_/Y VPWR VGND sg13g2_a21o_1
X_8572_ _9278_/D _5864_/Y _8563_/X _8571_/Y VPWR VGND sg13g2_o21ai_1
X_5784_ _5785_/C _7701_/C _7244_/D _7775_/D _5784_/D VPWR VGND sg13g2_nor4_1
XFILLER_61_382 VPWR VGND sg13g2_decap_8
XFILLER_22_769 VPWR VGND sg13g2_decap_8
X_4804_ _4804_/Y _4883_/A _9349_/Q VPWR VGND sg13g2_nor2b_1
XFILLER_119_112 VPWR VGND sg13g2_decap_8
X_4735_ _4739_/B _6037_/A _6018_/A _6018_/B _5392_/C VPWR VGND sg13g2_nand4_1
X_7523_ _7525_/B _7839_/C _7839_/B _9097_/Q VPWR VGND sg13g2_nor3_1
XFILLER_30_780 VPWR VGND sg13g2_fill_2
XFILLER_119_49 VPWR VGND sg13g2_fill_2
Xplace2310 _5890_/A _5735_/A VPWR VGND sg13g2_buf_1
X_4666_ _9645_/D _4666_/A _4666_/B VPWR VGND sg13g2_nor2_1
Xplace2321 _6438_/A _6262_/B VPWR VGND sg13g2_buf_1
X_7454_ _7458_/B _7448_/Y _7453_/Y _7512_/B1 VPWR VGND sg13g2_o21ai_1
Xplace2343 _5762_/A1 _9859_/A VPWR VGND sg13g2_buf_1
Xplace2354 _8092_/A _8403_/C VPWR VGND sg13g2_buf_1
Xplace2332 _4853_/A _4864_/A1 VPWR VGND sg13g2_buf_1
X_7385_ _7389_/B _9028_/Q _7385_/B VPWR VGND sg13g2_nor2_1
Xplace2365 _8383_/C _8056_/A VPWR VGND sg13g2_buf_1
X_6405_ _6405_/Y _9189_/Q _6173_/A _6506_/B1 _9065_/Q VPWR VGND sg13g2_a22oi_1
X_4597_ _8664_/D _9695_/Q _9706_/Q VPWR VGND sg13g2_or2_1
Xplace2398 place2398/X place2399/X VPWR VGND sg13g2_buf_1
X_6336_ _9375_/D _6491_/A2 _6334_/Y _6335_/Y VPWR VGND sg13g2_a21oi_1
X_9124_ _9124_/Q _9183_/CLK _9124_/D place2483/X VPWR VGND sg13g2_dfrbpq_1
Xplace2376 _8492_/C _5203_/A VPWR VGND sg13g2_buf_1
Xplace2387 _6506_/A2 _6410_/A VPWR VGND sg13g2_buf_1
Xhold3001 _6490_/B1 _9403_/Q VPWR VGND sg13g2_dlygate4sd3_1
X_9055_ _9055_/Q _9183_/CLK _9055_/D place2469/X VPWR VGND sg13g2_dfrbpq_1
Xhold3012 _4572_/A _9696_/Q VPWR VGND sg13g2_dlygate4sd3_1
Xhold3023 _8466_/B _9238_/Q VPWR VGND sg13g2_dlygate4sd3_1
XFILLER_76_408 VPWR VGND sg13g2_fill_1
Xhold3034 _8205_/A _9103_/Q VPWR VGND sg13g2_dlygate4sd3_1
Xhold3045 _8470_/B _9240_/Q VPWR VGND sg13g2_dlygate4sd3_1
Xhold3056 _6185_/B1 _9356_/Q VPWR VGND sg13g2_dlygate4sd3_1
X_6267_ _9367_/D _6267_/A VPWR VGND sg13g2_inv_1
Xhold3089 _8065_/A _9038_/Q VPWR VGND sg13g2_dlygate4sd3_1
Xhold3078 _4659_/A _8718_/Q VPWR VGND sg13g2_dlygate4sd3_1
Xhold3067 _7019_/A _8828_/Q VPWR VGND sg13g2_dlygate4sd3_1
X_8006_ _9013_/D _5367_/C _8011_/A _8005_/Y VPWR VGND sg13g2_o21ai_1
X_5218_ _5218_/Y _5216_/Y _5268_/C _5218_/C VPWR VGND sg13g2_nand3b_1
X_6198_ _6198_/X _8973_/Q _9035_/Q _9097_/Q _9159_/Q _6440_/S0 _6421_/S1 VPWR VGND
+ sg13g2_mux4_1
X_5149_ _5151_/B _9863_/A _5149_/B _5178_/A VPWR VGND sg13g2_nand3b_1
XFILLER_56_121 VPWR VGND sg13g2_fill_1
XFILLER_56_132 VPWR VGND sg13g2_fill_2
XFILLER_28_68 VPWR VGND sg13g2_fill_1
XFILLER_29_357 VPWR VGND sg13g2_fill_1
X_8908_ _8908_/Q _9611_/CLK _8908_/D place2412/X VPWR VGND sg13g2_dfrbpq_1
X_9888_ _9888_/X _9888_/A VPWR VGND sg13g2_buf_1
XFILLER_52_360 VPWR VGND sg13g2_fill_1
X_8839_ _8839_/Q _9242_/CLK _8839_/D place2496/X VPWR VGND sg13g2_dfrbpq_1
XFILLER_60_33 VPWR VGND sg13g2_decap_8
Xclkbuf_leaf_33_clk_i clkload5/A clkbuf_3_0__f_clk_i/X VPWR VGND sg13g2_buf_16
XFILLER_5_28 VPWR VGND sg13g2_decap_8
XFILLER_107_0 VPWR VGND sg13g2_fill_2
XFILLER_79_268 VPWR VGND sg13g2_decap_8
XFILLER_67_408 VPWR VGND sg13g2_fill_2
XFILLER_0_662 VPWR VGND sg13g2_decap_4
XFILLER_48_644 VPWR VGND sg13g2_fill_2
XFILLER_63_625 VPWR VGND sg13g2_fill_1
XFILLER_62_146 VPWR VGND sg13g2_fill_1
XFILLER_16_541 VPWR VGND sg13g2_decap_8
XFILLER_16_552 VPWR VGND sg13g2_fill_2
XFILLER_50_308 VPWR VGND sg13g2_fill_1
XFILLER_16_574 VPWR VGND sg13g2_decap_8
XFILLER_31_511 VPWR VGND sg13g2_fill_1
XFILLER_43_393 VPWR VGND sg13g2_decap_8
X_4520_ _4520_/Y _8819_/Q _6071_/C VPWR VGND sg13g2_nor2_1
X_4451_ _4452_/B _6539_/S _6962_/B VPWR VGND sg13g2_and2_1
X_7170_ _7170_/Y _6959_/Y _7168_/Y _7169_/Y VPWR VGND sg13g2_a21oi_1
XFILLER_98_522 VPWR VGND sg13g2_decap_8
X_6121_ _9349_/D _6131_/D _6120_/Y _6112_/Y VPWR VGND sg13g2_a21oi_1
X_4382_ _4382_/Y _9624_/Q _9626_/Q _9625_/Q VPWR VGND sg13g2_nor3_1
XFILLER_100_516 VPWR VGND sg13g2_decap_4
XFILLER_58_419 VPWR VGND sg13g2_fill_1
X_6052_ _6338_/D _6309_/B _6048_/Y _6379_/A2 VPWR VGND sg13g2_o21ai_1
XFILLER_22_0 VPWR VGND sg13g2_decap_8
X_5003_ _5005_/A _5008_/A _9373_/Q VPWR VGND sg13g2_nor2b_1
XFILLER_53_113 VPWR VGND sg13g2_fill_1
XFILLER_26_305 VPWR VGND sg13g2_decap_4
XFILLER_121_28 VPWR VGND sg13g2_decap_8
X_6954_ _9209_/D _9662_/Q _9209_/Q _6954_/S VPWR VGND sg13g2_mux2_1
XFILLER_93_293 VPWR VGND sg13g2_decap_8
X_5905_ _5905_/Y _5905_/A _5929_/B VPWR VGND sg13g2_nor2_1
X_9673_ _9673_/Q _9675_/CLK _9673_/D place2443/X VPWR VGND sg13g2_dfrbpq_1
X_6885_ _6885_/X _8916_/Q _8948_/Q _6901_/S VPWR VGND sg13g2_mux2_1
X_8624_ _8624_/Q _9678_/CLK _8624_/D fanout968/X VPWR VGND sg13g2_dfrbpq_1
XFILLER_22_511 VPWR VGND sg13g2_decap_8
X_5836_ _5836_/Y _7029_/A _7028_/C _5836_/C _5836_/D VPWR VGND sg13g2_nor4_1
XFILLER_14_59 VPWR VGND sg13g2_decap_8
XFILLER_22_577 VPWR VGND sg13g2_decap_8
X_8555_ _9270_/D _8555_/A VPWR VGND sg13g2_inv_1
X_5767_ _5767_/Y _5771_/A1 _9312_/Q _5771_/B1 VPWR VGND sg13g2_a21oi_1
X_4718_ _4718_/Y _9686_/Q _8741_/Q _9689_/Q _6956_/S VPWR VGND sg13g2_a22oi_1
X_5698_ _8602_/D _5698_/A VPWR VGND sg13g2_inv_1
XFILLER_30_14 VPWR VGND sg13g2_fill_2
X_7506_ _7506_/Y _7506_/A _7506_/B _7506_/C _7506_/D VPWR VGND sg13g2_nor4_1
X_8486_ _8486_/Y _8486_/A _8486_/B _8492_/C VPWR VGND sg13g2_nand3_1
X_4649_ _4649_/X _4652_/A _4651_/B VPWR VGND sg13g2_or2_1
Xplace2140 _5716_/C _5763_/B1 VPWR VGND sg13g2_buf_1
X_7437_ _7437_/Y _7437_/A _7437_/B _7437_/C VPWR VGND sg13g2_nand3_1
XFILLER_100_7 VPWR VGND sg13g2_decap_8
Xplace2173 _5160_/B _5086_/B VPWR VGND sg13g2_buf_1
Xplace2162 _7815_/B _4529_/Y VPWR VGND sg13g2_buf_1
Xplace2151 _4979_/A2 _4891_/A2 VPWR VGND sg13g2_buf_1
Xplace2195 _5597_/A _5525_/A VPWR VGND sg13g2_buf_1
X_7368_ _7371_/C _7369_/C _8996_/Q _7832_/C VPWR VGND sg13g2_nor3_1
Xplace2184 _7723_/C _7701_/C VPWR VGND sg13g2_buf_1
X_9107_ _9107_/Q clkload6/A _9107_/D place2434/X VPWR VGND sg13g2_dfrbpq_1
X_7299_ _7299_/Y _7299_/A _7299_/B _7299_/C _7299_/D VPWR VGND sg13g2_nor4_1
X_6319_ _6319_/Y _8862_/Q _6411_/A2 _6318_/X _6422_/B1 _6319_/C1 VPWR VGND sg13g2_a221oi_1
X_9038_ _9038_/Q _9603_/CLK _9038_/D place2411/X VPWR VGND sg13g2_dfrbpq_1
XFILLER_85_772 VPWR VGND sg13g2_decap_8
XFILLER_18_806 VPWR VGND sg13g2_fill_2
XFILLER_29_165 VPWR VGND sg13g2_decap_8
XFILLER_29_176 VPWR VGND sg13g2_fill_2
XFILLER_29_187 VPWR VGND sg13g2_decap_8
XFILLER_53_680 VPWR VGND sg13g2_decap_8
XFILLER_13_544 VPWR VGND sg13g2_decap_8
XFILLER_13_555 VPWR VGND sg13g2_decap_8
XFILLER_13_588 VPWR VGND sg13g2_decap_4
XFILLER_40_374 VPWR VGND sg13g2_decap_8
XFILLER_106_192 VPWR VGND sg13g2_fill_1
XFILLER_121_195 VPWR VGND sg13g2_decap_4
XFILLER_96_95 VPWR VGND sg13g2_fill_1
XFILLER_95_536 VPWR VGND sg13g2_decap_8
XFILLER_83_709 VPWR VGND sg13g2_fill_1
XFILLER_48_463 VPWR VGND sg13g2_decap_8
XFILLER_48_485 VPWR VGND sg13g2_fill_2
XFILLER_48_474 VPWR VGND sg13g2_decap_8
XFILLER_63_488 VPWR VGND sg13g2_decap_8
XFILLER_51_617 VPWR VGND sg13g2_decap_8
XFILLER_50_138 VPWR VGND sg13g2_fill_1
X_6670_ _9452_/D _6670_/A1 _6669_/Y _6668_/Y VPWR VGND sg13g2_o21ai_1
XFILLER_43_190 VPWR VGND sg13g2_decap_8
X_5621_ _5621_/Y _5621_/A _5621_/B VPWR VGND sg13g2_nand2_1
X_5552_ _5552_/Y _6617_/A _5579_/B VPWR VGND sg13g2_nand2_1
X_8340_ _9170_/D _8344_/A1 _8089_/Y _8339_/Y VPWR VGND sg13g2_o21ai_1
X_4503_ _7002_/D _4504_/A _4504_/B _4504_/C VPWR VGND sg13g2_nor3_1
X_8271_ _8271_/Y _8271_/A _8287_/B VPWR VGND sg13g2_nand2_1
X_5483_ _6561_/B _9635_/Q _9633_/Q _9634_/Q VPWR VGND sg13g2_nor3_1
X_7222_ _7222_/Y _8439_/A2 _7222_/A2 _7221_/Y VPWR VGND sg13g2_o21ai_1
X_4434_ _6018_/A _6348_/D _6037_/C _6046_/D _6043_/B VPWR VGND sg13g2_nor4_1
X_4365_ _6791_/B _9666_/Q _4365_/B VPWR VGND sg13g2_nor2_1
X_7153_ _7153_/Y _7156_/A _8870_/Q VPWR VGND sg13g2_nand2_1
XFILLER_101_803 VPWR VGND sg13g2_fill_2
XFILLER_58_205 VPWR VGND sg13g2_decap_4
X_6104_ _6104_/Y _6188_/A _6509_/C _6509_/D _6190_/D VPWR VGND sg13g2_nand4_1
X_7084_ _7084_/Y _5359_/C _7130_/A2 _7083_/Y VPWR VGND sg13g2_o21ai_1
X_4296_ _6049_/A _6046_/D VPWR VGND sg13g2_inv_1
X_6035_ _6410_/B _6035_/A _6158_/A VPWR VGND sg13g2_and2_1
XFILLER_39_452 VPWR VGND sg13g2_fill_2
XFILLER_27_636 VPWR VGND sg13g2_decap_8
XFILLER_26_135 VPWR VGND sg13g2_fill_1
XFILLER_81_252 VPWR VGND sg13g2_fill_1
XFILLER_54_488 VPWR VGND sg13g2_fill_2
X_7986_ _9003_/D _5357_/C _7985_/A _7985_/Y VPWR VGND sg13g2_o21ai_1
XFILLER_41_105 VPWR VGND sg13g2_fill_1
X_6937_ _6937_/X _9631_/Q _6937_/B _6939_/C VPWR VGND sg13g2_and3_1
XFILLER_35_680 VPWR VGND sg13g2_fill_1
X_9656_ _9656_/Q _9662_/CLK _9656_/D place2448/X VPWR VGND sg13g2_dfrbpq_1
X_6868_ _9600_/D _6867_/X _9600_/Q _6904_/S VPWR VGND sg13g2_mux2_1
X_5819_ _9302_/D _5819_/A VPWR VGND sg13g2_inv_1
X_9587_ _9587_/Q _9587_/CLK _9587_/D _9587_/RESET_B VPWR VGND sg13g2_dfrbpq_1
XFILLER_10_514 VPWR VGND sg13g2_decap_8
X_8607_ _8607_/Q _9701_/CLK _8607_/D fanout961/X VPWR VGND sg13g2_dfrbpq_1
X_8538_ _8538_/Y _8536_/A _8536_/B _9264_/Q VPWR VGND sg13g2_o21ai_1
X_6799_ _9552_/D _6798_/B _6797_/Y _6798_/Y VPWR VGND sg13g2_a21oi_1
XFILLER_10_558 VPWR VGND sg13g2_decap_8
XFILLER_6_518 VPWR VGND sg13g2_decap_8
XFILLER_41_46 VPWR VGND sg13g2_fill_2
XFILLER_108_457 VPWR VGND sg13g2_fill_1
X_8469_ _9239_/D _8474_/A _5353_/C _8468_/Y VPWR VGND sg13g2_o21ai_1
XFILLER_123_416 VPWR VGND sg13g2_decap_4
XFILLER_123_449 VPWR VGND sg13g2_fill_1
XFILLER_104_652 VPWR VGND sg13g2_fill_1
XFILLER_77_525 VPWR VGND sg13g2_decap_4
XFILLER_58_750 VPWR VGND sg13g2_fill_1
XFILLER_18_614 VPWR VGND sg13g2_fill_2
XFILLER_33_617 VPWR VGND sg13g2_decap_4
XFILLER_9_301 VPWR VGND sg13g2_fill_2
XFILLER_13_385 VPWR VGND sg13g2_decap_4
XFILLER_99_138 VPWR VGND sg13g2_decap_8
XFILLER_68_547 VPWR VGND sg13g2_fill_2
XFILLER_55_219 VPWR VGND sg13g2_fill_2
X_7840_ _7841_/D _9020_/Q _4550_/Y _7839_/Y VPWR VGND sg13g2_o21ai_1
XFILLER_91_561 VPWR VGND sg13g2_decap_8
XFILLER_36_488 VPWR VGND sg13g2_decap_4
X_7771_ _7772_/D _9884_/A _7771_/A2 _7788_/B1 _8859_/Q VPWR VGND sg13g2_a22oi_1
XFILLER_63_274 VPWR VGND sg13g2_decap_8
XFILLER_23_116 VPWR VGND sg13g2_fill_2
X_4983_ _4983_/Y _4983_/A _4983_/B _4983_/C VPWR VGND sg13g2_nand3_1
X_6722_ _9490_/D _9531_/Q _9490_/Q _6726_/S VPWR VGND sg13g2_mux2_1
X_9510_ _9510_/Q _9511_/CLK _9510_/D _9510_/RESET_B VPWR VGND sg13g2_dfrbpq_1
X_9441_ _9441_/Q _9582_/CLK _9441_/D fanout983/X VPWR VGND sg13g2_dfrbpq_1
X_6653_ _9447_/D _6653_/A1 _6652_/Y _6651_/Y VPWR VGND sg13g2_o21ai_1
X_5604_ _5604_/Y _8657_/Q _5498_/X _5500_/Y _8656_/Q VPWR VGND sg13g2_a22oi_1
X_6584_ _6584_/Y _9427_/Q _6587_/B VPWR VGND sg13g2_nand2_1
X_9372_ _9372_/Q _9406_/CLK _9372_/D place2489/X VPWR VGND sg13g2_dfrbpq_1
X_5535_ _5535_/Y _9431_/Q _5591_/B _5589_/B1 _8633_/Q VPWR VGND sg13g2_a22oi_1
X_8323_ _8323_/Y _8323_/A _8345_/B VPWR VGND sg13g2_nand2_1
XFILLER_117_265 VPWR VGND sg13g2_fill_2
Xoutput2730 master_we_o _4596_/Y VPWR VGND sg13g2_buf_1
X_5466_ _8691_/D _5466_/A _5468_/B_N VPWR VGND sg13g2_nor2b_1
X_8254_ _9127_/D _8286_/A1 _8056_/Y _8253_/Y VPWR VGND sg13g2_o21ai_1
Xoutput2741 slave_rdata_o[18] _4931_/Y VPWR VGND sg13g2_buf_1
Xoutput2752 slave_rdata_o[28] _5002_/Y VPWR VGND sg13g2_buf_1
X_4417_ _6509_/D _8446_/B _6333_/B VPWR VGND sg13g2_nor2_1
Xoutput2763 slave_rdata_o[9] _4854_/Y VPWR VGND sg13g2_buf_1
X_7205_ _7205_/Y _5365_/C _7222_/A2 _7204_/Y VPWR VGND sg13g2_o21ai_1
XFILLER_120_419 VPWR VGND sg13g2_decap_8
X_8185_ _8185_/Y _8185_/A _8191_/B VPWR VGND sg13g2_nand2_1
X_5397_ _5398_/D _7832_/C _7834_/A _9466_/Q VPWR VGND sg13g2_nand3_1
X_4348_ _4675_/A _4334_/Y _8715_/Q _9652_/Q VPWR VGND sg13g2_a21oi_1
XFILLER_101_611 VPWR VGND sg13g2_decap_8
XFILLER_99_694 VPWR VGND sg13g2_decap_8
XFILLER_86_300 VPWR VGND sg13g2_decap_4
XFILLER_59_536 VPWR VGND sg13g2_decap_8
X_7136_ _8864_/D _6975_/X _7133_/Y _7135_/Y VPWR VGND sg13g2_o21ai_1
XFILLER_86_344 VPWR VGND sg13g2_decap_8
X_7067_ _8842_/D _7066_/Y _8842_/Q _7085_/S VPWR VGND sg13g2_mux2_1
X_6018_ _6053_/B _6018_/A _6018_/B _6018_/C _6451_/A VPWR VGND sg13g2_nand4_1
XFILLER_55_753 VPWR VGND sg13g2_fill_1
XFILLER_36_46 VPWR VGND sg13g2_fill_2
XFILLER_54_241 VPWR VGND sg13g2_decap_8
XFILLER_54_296 VPWR VGND sg13g2_fill_1
X_7969_ _7969_/Y _7969_/A _8995_/Q _8361_/C VPWR VGND sg13g2_nand3_1
XFILLER_15_628 VPWR VGND sg13g2_decap_8
XFILLER_70_789 VPWR VGND sg13g2_fill_1
X_9708_ _9708_/Q _9708_/CLK _9708_/D fanout953/X VPWR VGND sg13g2_dfrbpq_1
XFILLER_42_447 VPWR VGND sg13g2_fill_1
X_9639_ _9639_/Q _9649_/CLK _9639_/D fanout973/X VPWR VGND sg13g2_dfrbpq_1
XFILLER_22_160 VPWR VGND sg13g2_decap_8
XFILLER_22_171 VPWR VGND sg13g2_fill_1
XFILLER_117_71 VPWR VGND sg13g2_fill_2
XFILLER_2_598 VPWR VGND sg13g2_fill_2
XFILLER_77_97 VPWR VGND sg13g2_fill_1
XFILLER_46_786 VPWR VGND sg13g2_decap_4
X_9531__2849 _9531_/RESET_B VPWR VGND sg13g2_tiehi
XFILLER_73_583 VPWR VGND sg13g2_fill_1
XFILLER_33_425 VPWR VGND sg13g2_fill_2
XFILLER_14_661 VPWR VGND sg13g2_decap_8
XFILLER_13_193 VPWR VGND sg13g2_decap_8
XFILLER_41_491 VPWR VGND sg13g2_decap_8
X_5320_ _5322_/A _5315_/A _5254_/C _5339_/D VPWR VGND sg13g2_o21ai_1
XFILLER_114_235 VPWR VGND sg13g2_fill_2
X_5251_ _8769_/D _5288_/B2 _8483_/A2 _5250_/Y VPWR VGND sg13g2_o21ai_1
XFILLER_96_631 VPWR VGND sg13g2_decap_8
X_5182_ _5182_/Y _5173_/Y _5179_/X _5074_/Y VPWR VGND sg13g2_a21oi_1
XFILLER_95_130 VPWR VGND sg13g2_fill_2
XFILLER_68_355 VPWR VGND sg13g2_decap_4
XFILLER_68_333 VPWR VGND sg13g2_fill_2
XFILLER_110_474 VPWR VGND sg13g2_fill_2
XFILLER_110_463 VPWR VGND sg13g2_decap_8
X_8941_ _8941_/Q _9611_/CLK _8941_/D place2414/X VPWR VGND sg13g2_dfrbpq_1
XFILLER_95_163 VPWR VGND sg13g2_decap_8
XFILLER_68_366 VPWR VGND sg13g2_decap_8
XFILLER_56_539 VPWR VGND sg13g2_decap_8
XFILLER_95_196 VPWR VGND sg13g2_fill_2
X_8872_ _8872_/Q _9251_/CLK _8872_/D place2479/X VPWR VGND sg13g2_dfrbpq_1
XFILLER_64_594 VPWR VGND sg13g2_decap_8
XFILLER_52_723 VPWR VGND sg13g2_decap_4
X_7823_ _7827_/B _7817_/Y _7822_/Y _8056_/D VPWR VGND sg13g2_o21ai_1
X_7754_ _7754_/Y _7811_/A _7811_/B _7811_/C _7754_/D VPWR VGND sg13g2_nor4_1
X_9507__2873 _9507_/RESET_B VPWR VGND sg13g2_tiehi
Xinput2606 _5883_/B1 master_rdata_i[6] VPWR VGND sg13g2_buf_1
X_6705_ _9473_/D _9514_/Q _9473_/Q _6710_/S VPWR VGND sg13g2_mux2_1
X_4966_ _4966_/Y _9399_/Q _4979_/A2 _4964_/Y VPWR VGND sg13g2_a21oi_1
X_7685_ _7685_/X _7747_/A _9012_/Q _7747_/C VPWR VGND sg13g2_or3_1
Xinput2617 _6064_/B slave_addr_i[9] VPWR VGND sg13g2_buf_1
Xinput2628 _7179_/A slave_wdata_i[14] VPWR VGND sg13g2_buf_1
Xinput2639 _7214_/B slave_wdata_i[24] VPWR VGND sg13g2_buf_1
X_4897_ _4897_/Y _4945_/C _4999_/B _4998_/A VPWR VGND sg13g2_nand3b_1
X_6636_ _6636_/Y _8644_/Q _6666_/A2 _6635_/X VPWR VGND sg13g2_o21ai_1
X_9424_ _9424_/Q _9587_/CLK _9424_/D fanout978/X VPWR VGND sg13g2_dfrbpq_1
X_6567_ _6567_/X _6672_/A _9556_/Q _6672_/C VPWR VGND sg13g2_or3_1
X_9355_ _9355_/Q clkload9/A _9355_/D place2505/X VPWR VGND sg13g2_dfrbpq_1
XFILLER_106_714 VPWR VGND sg13g2_decap_8
X_5518_ _8627_/D _5517_/Y _5516_/Y _6546_/D VPWR VGND sg13g2_a21oi_1
X_8306_ _9153_/D _8350_/A1 _8042_/Y _8305_/Y VPWR VGND sg13g2_o21ai_1
X_9286_ _9286_/Q _9410_/CLK _9286_/D place2395/X VPWR VGND sg13g2_dfrbpq_1
XFILLER_105_213 VPWR VGND sg13g2_decap_8
X_6498_ _9404_/D _6496_/Y _6505_/A2 _6497_/Y VPWR VGND sg13g2_a21oi_1
X_8237_ _8237_/Y _8237_/A _8251_/B VPWR VGND sg13g2_nand2_1
X_5449_ _5450_/A _5455_/A1 _8683_/Q _8684_/Q _5451_/B2 VPWR VGND sg13g2_a22oi_1
XFILLER_121_739 VPWR VGND sg13g2_decap_8
XFILLER_120_216 VPWR VGND sg13g2_decap_8
X_9581__2809 _9581_/RESET_B VPWR VGND sg13g2_tiehi
XFILLER_114_780 VPWR VGND sg13g2_decap_4
X_8168_ _9084_/D _8190_/A1 _7889_/Y _8167_/Y VPWR VGND sg13g2_o21ai_1
XFILLER_113_290 VPWR VGND sg13g2_decap_8
XFILLER_75_804 VPWR VGND sg13g2_fill_1
XFILLER_59_333 VPWR VGND sg13g2_fill_1
X_7119_ _8859_/D _7118_/Y _8859_/Q _7131_/S VPWR VGND sg13g2_mux2_1
XFILLER_87_697 VPWR VGND sg13g2_fill_2
XFILLER_86_152 VPWR VGND sg13g2_decap_8
XFILLER_47_528 VPWR VGND sg13g2_fill_1
X_8099_ _8099_/Y _9050_/Q _8099_/B VPWR VGND sg13g2_nand2_1
XFILLER_47_45 VPWR VGND sg13g2_fill_1
XFILLER_47_78 VPWR VGND sg13g2_decap_8
XFILLER_55_561 VPWR VGND sg13g2_fill_2
XFILLER_63_11 VPWR VGND sg13g2_decap_8
XFILLER_15_403 VPWR VGND sg13g2_fill_1
XFILLER_15_458 VPWR VGND sg13g2_fill_1
XFILLER_8_28 VPWR VGND sg13g2_decap_8
XFILLER_11_653 VPWR VGND sg13g2_decap_8
XFILLER_7_602 VPWR VGND sg13g2_decap_8
XFILLER_10_174 VPWR VGND sg13g2_fill_1
X_9557__2833 _9557_/RESET_B VPWR VGND sg13g2_tiehi
XFILLER_2_351 VPWR VGND sg13g2_fill_1
XFILLER_92_111 VPWR VGND sg13g2_decap_8
XFILLER_46_550 VPWR VGND sg13g2_fill_1
XFILLER_46_561 VPWR VGND sg13g2_fill_1
XFILLER_18_285 VPWR VGND sg13g2_decap_8
X_4820_ _4833_/A _4776_/B _4820_/B VPWR VGND sg13g2_nand2b_1
XFILLER_61_564 VPWR VGND sg13g2_decap_8
X_4751_ _4751_/Y _9376_/Q _8817_/Q VPWR VGND sg13g2_nand2b_1
X_4682_ _9660_/D _4682_/A _4687_/A VPWR VGND sg13g2_nor2_1
X_7470_ _7471_/D _9032_/Q _7491_/B _7467_/Y VPWR VGND sg13g2_o21ai_1
Xplace2503 place2503/X place2504/X VPWR VGND sg13g2_buf_1
Xplace2514 _6377_/S0 _6381_/S0 VPWR VGND sg13g2_buf_1
X_6421_ _6421_/X _9006_/Q _9068_/Q _9130_/Q _9192_/Q _6421_/S0 _6421_/S1 VPWR VGND
+ sg13g2_mux4_1
X_9140_ _9140_/Q _9504_/CLK _9140_/D place2432/X VPWR VGND sg13g2_dfrbpq_1
Xplace1802 _5269_/A1 _5288_/B2 VPWR VGND sg13g2_buf_1
Xplace2536 _7210_/D _7207_/B VPWR VGND sg13g2_buf_1
Xplace2525 _6381_/S1 _6363_/S1 VPWR VGND sg13g2_buf_1
XFILLER_115_522 VPWR VGND sg13g2_decap_8
Xplace1824 _8097_/B _8094_/B VPWR VGND sg13g2_buf_1
XFILLER_52_0 VPWR VGND sg13g2_fill_2
Xplace1813 _8375_/A _8355_/A VPWR VGND sg13g2_buf_1
X_6352_ _9378_/D _9378_/Q _6392_/S _6351_/Y VPWR VGND sg13g2_a21o_1
Xplace1835 _7975_/A _7969_/A VPWR VGND sg13g2_buf_1
Xplace1857 _5978_/B _5963_/B VPWR VGND sg13g2_buf_1
XFILLER_115_555 VPWR VGND sg13g2_decap_8
Xhold3205 _6654_/A _9448_/Q VPWR VGND sg13g2_dlygate4sd3_1
Xplace1879 _7830_/S _7793_/S VPWR VGND sg13g2_buf_1
X_9071_ _9071_/Q _9611_/CLK _9071_/D place2413/X VPWR VGND sg13g2_dfrbpq_1
X_5303_ _5370_/C _5319_/A _9497_/Q VPWR VGND sg13g2_nand2_1
Xplace1846 _7953_/A _7934_/A VPWR VGND sg13g2_buf_1
X_6283_ _6283_/Y _6475_/A _6509_/B _6323_/C _6438_/A VPWR VGND sg13g2_nand4_1
Xplace1868 _8490_/A _8492_/A VPWR VGND sg13g2_buf_1
X_5234_ _5235_/B _5234_/A _9873_/A _5234_/C _5242_/C VPWR VGND sg13g2_nor4_1
X_8022_ _8022_/Y _8039_/A _8039_/B _8039_/C _8022_/D VPWR VGND sg13g2_nand4_1
Xhold3249 _4403_/B1 _8670_/Q VPWR VGND sg13g2_dlygate4sd3_1
Xhold3227 _8297_/A _9149_/Q VPWR VGND sg13g2_dlygate4sd3_1
Xhold3216 _5695_/B2 _8601_/Q VPWR VGND sg13g2_dlygate4sd3_1
Xhold3238 _5660_/A _8608_/Q VPWR VGND sg13g2_dlygate4sd3_1
XFILLER_111_750 VPWR VGND sg13g2_fill_2
X_5165_ _5165_/Y _5151_/A _5151_/B _5191_/A VPWR VGND sg13g2_a21oi_1
XFILLER_96_472 VPWR VGND sg13g2_decap_8
X_5096_ _5098_/D _5110_/A _5123_/B _5096_/C VPWR VGND sg13g2_nor3_1
XFILLER_83_122 VPWR VGND sg13g2_decap_8
X_8924_ _8924_/Q _9611_/CLK _8924_/D place2416/X VPWR VGND sg13g2_dfrbpq_1
XFILLER_84_667 VPWR VGND sg13g2_fill_1
XFILLER_25_701 VPWR VGND sg13g2_decap_8
XFILLER_71_339 VPWR VGND sg13g2_decap_8
X_8855_ _8855_/Q _9253_/CLK _8855_/D place2487/X VPWR VGND sg13g2_dfrbpq_1
XFILLER_25_734 VPWR VGND sg13g2_decap_4
X_7806_ _7806_/Y _7806_/A _7806_/B _7806_/C _7806_/D VPWR VGND sg13g2_nor4_1
XFILLER_52_531 VPWR VGND sg13g2_decap_4
X_5998_ _5998_/Y _5998_/A _5998_/B _6004_/C VPWR VGND sg13g2_nand3_1
X_8786_ _8786_/Q _9254_/CLK _8786_/D place2423/X VPWR VGND sg13g2_dfrbpq_1
XFILLER_12_406 VPWR VGND sg13g2_decap_8
XFILLER_40_704 VPWR VGND sg13g2_decap_8
X_7737_ _7738_/A _8858_/Q _7846_/A2 _7737_/B1 _7737_/B2 VPWR VGND sg13g2_a22oi_1
XFILLER_12_439 VPWR VGND sg13g2_decap_8
X_4949_ _4949_/Y _4791_/B _4913_/Y _4948_/Y VPWR VGND sg13g2_o21ai_1
X_7668_ _7672_/D _9166_/Q _7725_/B _7667_/A VPWR VGND sg13g2_o21ai_1
X_6619_ _6619_/Y _8639_/Q _6666_/A2 _6618_/X VPWR VGND sg13g2_o21ai_1
X_9407_ _9407_/Q _9407_/CLK _9407_/D place2455/X VPWR VGND sg13g2_dfrbpq_1
X_7599_ _7600_/B _9215_/Q _7695_/A2 _7771_/A2 _9876_/A VPWR VGND sg13g2_a22oi_1
XFILLER_4_649 VPWR VGND sg13g2_decap_8
X_9338_ _9338_/Q _9414_/CLK _9338_/D place2504/X VPWR VGND sg13g2_dfrbpq_1
X_9269_ _9269_/Q _9304_/CLK _9269_/D place2414/X VPWR VGND sg13g2_dfrbpq_1
XFILLER_58_11 VPWR VGND sg13g2_fill_1
XFILLER_59_130 VPWR VGND sg13g2_fill_2
XFILLER_58_55 VPWR VGND sg13g2_fill_1
XFILLER_58_44 VPWR VGND sg13g2_decap_8
XFILLER_87_472 VPWR VGND sg13g2_fill_2
XFILLER_75_612 VPWR VGND sg13g2_decap_8
XFILLER_74_100 VPWR VGND sg13g2_fill_1
XFILLER_47_325 VPWR VGND sg13g2_fill_2
XFILLER_63_807 VPWR VGND sg13g2_fill_2
XFILLER_74_188 VPWR VGND sg13g2_fill_1
XFILLER_15_222 VPWR VGND sg13g2_fill_1
XFILLER_88_9 VPWR VGND sg13g2_fill_1
XFILLER_30_269 VPWR VGND sg13g2_decap_8
XFILLER_23_80 VPWR VGND sg13g2_decap_4
XFILLER_109_382 VPWR VGND sg13g2_decap_8
X_9481__2899 _9481_/RESET_B VPWR VGND sg13g2_tiehi
XFILLER_98_715 VPWR VGND sg13g2_decap_8
XFILLER_112_503 VPWR VGND sg13g2_decap_8
XFILLER_3_660 VPWR VGND sg13g2_fill_1
XFILLER_112_558 VPWR VGND sg13g2_decap_8
XFILLER_2_170 VPWR VGND sg13g2_decap_8
XFILLER_120_591 VPWR VGND sg13g2_decap_8
XFILLER_78_483 VPWR VGND sg13g2_decap_8
X_6970_ _6970_/Y _5375_/C _7127_/A2 _6969_/Y VPWR VGND sg13g2_o21ai_1
XFILLER_26_509 VPWR VGND sg13g2_fill_2
X_5921_ _5921_/Y _5921_/A _5929_/B VPWR VGND sg13g2_nor2_1
XFILLER_81_637 VPWR VGND sg13g2_decap_8
XFILLER_19_561 VPWR VGND sg13g2_decap_8
XFILLER_0_84 VPWR VGND sg13g2_decap_4
X_5852_ _5852_/Y _5939_/A _5849_/X _5925_/C VPWR VGND sg13g2_o21ai_1
X_8640_ _8640_/Q _9449_/CLK _8640_/D fanout980/X VPWR VGND sg13g2_dfrbpq_1
X_8571_ _8571_/Y _8577_/A _8577_/B _9278_/Q VPWR VGND sg13g2_nand3_1
X_5783_ _7024_/D _5827_/A _7461_/C VPWR VGND sg13g2_nand2_1
X_4803_ _4803_/Y _4864_/A1 _4801_/Y _4802_/Y VPWR VGND sg13g2_o21ai_1
XFILLER_22_759 VPWR VGND sg13g2_fill_1
X_4734_ _6065_/A _6071_/A _9692_/Q VPWR VGND sg13g2_nand2b_1
X_7522_ _7525_/A _9190_/Q _7815_/B VPWR VGND sg13g2_nor2_1
XFILLER_119_28 VPWR VGND sg13g2_decap_8
XFILLER_107_319 VPWR VGND sg13g2_fill_2
Xplace2311 _5735_/A _5110_/A VPWR VGND sg13g2_buf_1
X_4665_ _4666_/B _9645_/Q _4665_/B VPWR VGND sg13g2_nor2_1
Xplace2300 _4820_/B _9339_/Q VPWR VGND sg13g2_buf_1
X_7453_ _7453_/Y _7489_/A _7453_/B _7453_/C _7453_/D VPWR VGND sg13g2_nor4_1
Xplace2322 _6262_/B _9245_/Q VPWR VGND sg13g2_buf_1
X_4596_ _4596_/Y _9410_/Q _9408_/Q _6534_/C VPWR VGND sg13g2_nor3_1
Xplace2355 _8403_/C _8389_/C VPWR VGND sg13g2_buf_1
Xplace2344 _9859_/A _8753_/Q VPWR VGND sg13g2_buf_1
Xplace2333 _4864_/A1 _8817_/Q VPWR VGND sg13g2_buf_1
X_7384_ _7384_/Y _7384_/A _7384_/B _7384_/C _7384_/D VPWR VGND sg13g2_nor4_1
X_6404_ _6404_/Y _9003_/Q _6410_/A _6404_/B1 _9127_/Q VPWR VGND sg13g2_a22oi_1
XFILLER_89_715 VPWR VGND sg13g2_fill_2
X_6335_ _6335_/Y _6312_/C _6312_/A _6335_/B1 VPWR VGND sg13g2_a21oi_1
Xplace2388 _7229_/B1 _7237_/B1 VPWR VGND sg13g2_buf_1
Xplace2377 _8371_/C _8355_/C VPWR VGND sg13g2_buf_1
X_9123_ _9123_/Q _9188_/CLK _9123_/D place2483/X VPWR VGND sg13g2_dfrbpq_1
Xplace2366 _8365_/C _8361_/C VPWR VGND sg13g2_buf_1
Xhold3013 _6638_/A _9443_/Q VPWR VGND sg13g2_dlygate4sd3_1
Xplace2399 place2399/X place2400/X VPWR VGND sg13g2_buf_1
Xhold3002 _8219_/A _9110_/Q VPWR VGND sg13g2_dlygate4sd3_1
Xhold3024 _8195_/A _9098_/Q VPWR VGND sg13g2_dlygate4sd3_1
X_9054_ _9054_/Q _9188_/CLK _9054_/D place2485/X VPWR VGND sg13g2_dfrbpq_1
XFILLER_88_258 VPWR VGND sg13g2_decap_8
X_8005_ _8005_/Y _8011_/A _8005_/B _8414_/C VPWR VGND sg13g2_nand3_1
Xhold3046 _5685_/B2 _8596_/Q VPWR VGND sg13g2_dlygate4sd3_1
Xhold3057 _8165_/A _9083_/Q VPWR VGND sg13g2_dlygate4sd3_1
X_6266_ _6267_/A _9367_/Q _6279_/A _6265_/Y VPWR VGND sg13g2_o21ai_1
Xhold3035 _5647_/B2 _8615_/Q VPWR VGND sg13g2_dlygate4sd3_1
XFILLER_97_770 VPWR VGND sg13g2_fill_2
X_5217_ _5217_/Y _5238_/A _5243_/B VPWR VGND sg13g2_nand2_1
XFILLER_57_601 VPWR VGND sg13g2_fill_2
Xhold3068 _8229_/A _9115_/Q VPWR VGND sg13g2_dlygate4sd3_1
Xhold3079 _5691_/B2 _8599_/Q VPWR VGND sg13g2_dlygate4sd3_1
X_6197_ _9357_/D _6193_/Y _6196_/Y _6195_/Y VPWR VGND sg13g2_a21oi_1
X_5148_ _5151_/A _5150_/B _9863_/A VPWR VGND sg13g2_nand2_1
X_5079_ _5268_/C _7025_/A _5235_/A VPWR VGND sg13g2_nor2_1
XFILLER_57_656 VPWR VGND sg13g2_decap_8
XFILLER_29_369 VPWR VGND sg13g2_decap_8
X_8907_ _8907_/Q _9504_/CLK _8907_/D place2428/X VPWR VGND sg13g2_dfrbpq_1
XFILLER_44_317 VPWR VGND sg13g2_fill_1
XFILLER_44_328 VPWR VGND sg13g2_decap_8
XFILLER_44_339 VPWR VGND sg13g2_fill_1
X_9887_ _9887_/X _9887_/A VPWR VGND sg13g2_buf_1
XFILLER_71_158 VPWR VGND sg13g2_decap_8
XFILLER_25_531 VPWR VGND sg13g2_fill_2
XFILLER_37_380 VPWR VGND sg13g2_fill_1
X_8838_ _8838_/Q _9692_/CLK _8838_/D place2496/X VPWR VGND sg13g2_dfrbpq_1
X_8769_ _9875_/A _9252_/CLK _8769_/D place2391/X VPWR VGND sg13g2_dfrbpq_1
XFILLER_40_523 VPWR VGND sg13g2_fill_2
XFILLER_100_74 VPWR VGND sg13g2_decap_8
XFILLER_60_23 VPWR VGND sg13g2_fill_1
XFILLER_21_781 VPWR VGND sg13g2_fill_2
XFILLER_60_89 VPWR VGND sg13g2_fill_2
XFILLER_69_32 VPWR VGND sg13g2_fill_2
X_9466__2914 _9466_/RESET_B VPWR VGND sg13g2_tiehi
XFILLER_85_75 VPWR VGND sg13g2_fill_1
XFILLER_62_114 VPWR VGND sg13g2_decap_8
XFILLER_35_306 VPWR VGND sg13g2_fill_2
XFILLER_90_434 VPWR VGND sg13g2_decap_4
XFILLER_16_520 VPWR VGND sg13g2_fill_2
XFILLER_90_489 VPWR VGND sg13g2_decap_4
XFILLER_90_467 VPWR VGND sg13g2_fill_2
XFILLER_62_158 VPWR VGND sg13g2_decap_8
XFILLER_16_597 VPWR VGND sg13g2_decap_4
XFILLER_31_589 VPWR VGND sg13g2_decap_4
X_4450_ _6047_/A _8589_/A _6338_/B VPWR VGND sg13g2_nor2_1
X_4381_ _8707_/D _9641_/D VPWR VGND sg13g2_inv_1
X_6120_ _6120_/Y _8838_/Q _6130_/B _6119_/X _6129_/A _6118_/Y VPWR VGND sg13g2_a221oi_1
XFILLER_86_718 VPWR VGND sg13g2_fill_1
X_6051_ _6131_/D _6275_/B _6371_/A VPWR VGND sg13g2_nor2_1
XFILLER_112_388 VPWR VGND sg13g2_fill_1
X_5002_ _5002_/Y _5006_/A1 _4997_/Y _5001_/Y VPWR VGND sg13g2_o21ai_1
XFILLER_39_645 VPWR VGND sg13g2_decap_8
XFILLER_66_464 VPWR VGND sg13g2_fill_2
XFILLER_54_604 VPWR VGND sg13g2_fill_1
XFILLER_15_0 VPWR VGND sg13g2_decap_8
XFILLER_39_667 VPWR VGND sg13g2_decap_8
XFILLER_94_795 VPWR VGND sg13g2_fill_1
XFILLER_81_412 VPWR VGND sg13g2_fill_1
X_6953_ _9210_/D _9649_/Q _9210_/Q _6953_/S VPWR VGND sg13g2_mux2_1
X_6884_ _9608_/D _6883_/X _9608_/Q _6910_/S VPWR VGND sg13g2_mux2_1
X_5904_ _5904_/Y _9315_/Q _5963_/B VPWR VGND sg13g2_nand2_1
X_9672_ _9672_/Q _9672_/CLK _9672_/D place2441/X VPWR VGND sg13g2_dfrbpq_1
X_5835_ _5835_/X _5832_/Y _5833_/Y _5834_/Y VPWR VGND sg13g2_a21o_1
X_8623_ _8623_/Q _9689_/CLK _8623_/D fanout959/X VPWR VGND sg13g2_dfrbpq_1
X_8554_ _8555_/A _9270_/Q _8560_/A2 _8560_/B1 _9496_/Q VPWR VGND sg13g2_a22oi_1
X_5766_ _5766_/Y _9320_/Q _5765_/B _5765_/Y VPWR VGND sg13g2_o21ai_1
XFILLER_10_729 VPWR VGND sg13g2_decap_8
X_9544__2836 _9544_/RESET_B VPWR VGND sg13g2_tiehi
X_4717_ _4723_/A _9684_/Q _8741_/Q _9687_/Q VPWR VGND sg13g2_a21oi_1
X_5697_ _5698_/A _5699_/B2 _5624_/X _5629_/Y _5697_/B2 VPWR VGND sg13g2_a22oi_1
X_7505_ _7506_/D _7819_/C _9127_/Q _7820_/C VPWR VGND sg13g2_nor3_1
X_8485_ _9247_/D _8486_/A _5362_/C _8484_/Y VPWR VGND sg13g2_o21ai_1
XFILLER_107_127 VPWR VGND sg13g2_fill_2
X_7436_ _7437_/C _9283_/Q _7796_/A2 _7796_/B1 _9315_/Q VPWR VGND sg13g2_a22oi_1
X_4648_ _4651_/B _9459_/Q _9460_/Q _8718_/Q VPWR VGND sg13g2_nor3_1
Xplace2130 _5365_/C _5270_/Y VPWR VGND sg13g2_buf_1
XFILLER_116_650 VPWR VGND sg13g2_decap_8
Xplace2141 _5772_/A1 _5771_/B1 VPWR VGND sg13g2_buf_1
Xplace2163 _6369_/D _6153_/D VPWR VGND sg13g2_buf_1
Xplace2152 _4891_/A2 _4770_/Y VPWR VGND sg13g2_buf_1
Xplace2174 _5124_/A _5086_/A VPWR VGND sg13g2_buf_1
XFILLER_89_523 VPWR VGND sg13g2_decap_8
X_9106_ _9106_/Q _9199_/CLK _9106_/D place2425/X VPWR VGND sg13g2_dfrbpq_1
Xplace2196 _5525_/A _5625_/B VPWR VGND sg13g2_buf_1
X_4579_ _9702_/D _4590_/C _4579_/B VPWR VGND sg13g2_and2_1
X_7367_ _7371_/B _7369_/C _7404_/B _8965_/Q VPWR VGND sg13g2_nor3_1
Xplace2185 _7701_/C _5343_/B VPWR VGND sg13g2_buf_1
XFILLER_116_694 VPWR VGND sg13g2_decap_8
XFILLER_103_333 VPWR VGND sg13g2_fill_1
XFILLER_89_556 VPWR VGND sg13g2_decap_8
XFILLER_89_545 VPWR VGND sg13g2_decap_8
X_7298_ _7299_/D _9023_/Q _7291_/B _7296_/Y VPWR VGND sg13g2_o21ai_1
X_6318_ _6318_/X _8988_/Q _9050_/Q _9112_/Q _9174_/Q _6421_/S0 _6400_/S1 VPWR VGND
+ sg13g2_mux4_1
XFILLER_103_355 VPWR VGND sg13g2_decap_8
X_6249_ _6249_/Y _6410_/A _6249_/B _6249_/C VPWR VGND sg13g2_nor3_1
X_9037_ _9037_/Q _9501_/CLK _9037_/D place2470/X VPWR VGND sg13g2_dfrbpq_1
XFILLER_85_751 VPWR VGND sg13g2_decap_8
XFILLER_57_431 VPWR VGND sg13g2_decap_8
XFILLER_72_412 VPWR VGND sg13g2_fill_1
XFILLER_72_401 VPWR VGND sg13g2_decap_8
XFILLER_57_486 VPWR VGND sg13g2_fill_1
XFILLER_57_475 VPWR VGND sg13g2_decap_8
XFILLER_72_478 VPWR VGND sg13g2_fill_1
XFILLER_72_467 VPWR VGND sg13g2_decap_8
XFILLER_111_62 VPWR VGND sg13g2_fill_2
XFILLER_13_512 VPWR VGND sg13g2_decap_8
XFILLER_71_44 VPWR VGND sg13g2_decap_4
XFILLER_71_88 VPWR VGND sg13g2_decap_4
XFILLER_9_538 VPWR VGND sg13g2_decap_8
XFILLER_106_160 VPWR VGND sg13g2_decap_4
XFILLER_5_777 VPWR VGND sg13g2_decap_8
XFILLER_4_254 VPWR VGND sg13g2_decap_8
XFILLER_122_631 VPWR VGND sg13g2_fill_1
XFILLER_68_707 VPWR VGND sg13g2_fill_1
XFILLER_122_697 VPWR VGND sg13g2_decap_8
XFILLER_67_217 VPWR VGND sg13g2_decap_8
XFILLER_36_604 VPWR VGND sg13g2_fill_1
XFILLER_36_615 VPWR VGND sg13g2_decap_8
XFILLER_75_283 VPWR VGND sg13g2_decap_8
XFILLER_35_147 VPWR VGND sg13g2_decap_8
XFILLER_90_297 VPWR VGND sg13g2_fill_2
XFILLER_16_383 VPWR VGND sg13g2_decap_8
XFILLER_31_331 VPWR VGND sg13g2_fill_2
X_5620_ _8661_/D _5619_/Y _5618_/Y _5623_/B1 VPWR VGND sg13g2_a21oi_1
X_5551_ _8638_/D _5550_/Y _5549_/Y _5587_/B1 VPWR VGND sg13g2_a21oi_1
X_4502_ _4504_/C _9256_/Q _9257_/Q VPWR VGND sg13g2_nor2b_1
X_8270_ _9135_/D _8288_/A1 _8077_/Y _8269_/Y VPWR VGND sg13g2_o21ai_1
X_5482_ _5482_/Y _9634_/Q _6951_/C _5479_/Y VPWR VGND sg13g2_o21ai_1
X_7221_ _7221_/Y _7221_/A _7221_/B _7221_/C _7221_/D VPWR VGND sg13g2_nand4_1
XFILLER_8_593 VPWR VGND sg13g2_decap_8
X_4433_ _4517_/B _6348_/D _6046_/D _6043_/B VPWR VGND sg13g2_nor3_1
XFILLER_113_620 VPWR VGND sg13g2_decap_4
X_4364_ _4365_/B _9208_/Q _9670_/Q _9673_/Q _4598_/B VPWR VGND sg13g2_nor4_1
X_7152_ _7152_/Y _7902_/D _6977_/Y _7132_/Y _4435_/D VPWR VGND sg13g2_a22oi_1
XFILLER_98_375 VPWR VGND sg13g2_fill_1
XFILLER_86_515 VPWR VGND sg13g2_decap_8
X_6103_ _6103_/Y _6322_/B _6103_/B _8474_/B _6224_/A VPWR VGND sg13g2_nand4_1
X_4295_ _6451_/A _6035_/A VPWR VGND sg13g2_inv_1
X_7083_ _7083_/Y _7182_/B _7182_/D _7105_/C VPWR VGND sg13g2_nand3_1
X_6034_ _6365_/B _6041_/A _6043_/B _8589_/A VPWR VGND sg13g2_a21oi_1
XFILLER_86_559 VPWR VGND sg13g2_decap_8
XFILLER_54_412 VPWR VGND sg13g2_fill_2
Xclkbuf_leaf_32_clk_i _9188_/CLK clkbuf_3_0__f_clk_i/X VPWR VGND sg13g2_buf_16
XFILLER_27_604 VPWR VGND sg13g2_decap_8
XFILLER_26_125 VPWR VGND sg13g2_decap_4
X_7985_ _7985_/Y _7985_/A _9003_/Q _8409_/C VPWR VGND sg13g2_nand3_1
XFILLER_39_497 VPWR VGND sg13g2_fill_1
X_6936_ _9630_/D _6928_/Y _6934_/Y _6935_/Y VPWR VGND sg13g2_o21ai_1
XFILLER_42_629 VPWR VGND sg13g2_decap_8
XFILLER_41_117 VPWR VGND sg13g2_decap_4
XFILLER_41_128 VPWR VGND sg13g2_fill_1
X_9655_ _9655_/Q _9662_/CLK _9655_/D place2445/X VPWR VGND sg13g2_dfrbpq_1
X_6867_ _6867_/X _8907_/Q _8939_/Q _9255_/Q VPWR VGND sg13g2_mux2_1
X_5818_ _5819_/A _9302_/Q _5786_/Y _5787_/Y _9499_/Q VPWR VGND sg13g2_a22oi_1
X_9586_ _9586_/Q _9587_/CLK _9586_/D _9586_/RESET_B VPWR VGND sg13g2_dfrbpq_1
X_6798_ _6798_/Y _9552_/Q _6798_/B VPWR VGND sg13g2_nor2_1
XFILLER_50_695 VPWR VGND sg13g2_fill_2
X_8606_ _8606_/Q _9708_/CLK _8606_/D fanout961/X VPWR VGND sg13g2_dfrbpq_1
X_8537_ _9263_/D _8536_/Y _8534_/Y _8529_/Y VPWR VGND sg13g2_o21ai_1
X_5749_ _5749_/Y _9324_/Q _5749_/B VPWR VGND sg13g2_nand2b_1
X_8468_ _8468_/Y _8474_/A _8468_/B _8490_/C VPWR VGND sg13g2_nand3_1
X_7419_ _7419_/Y _7419_/A _7576_/S VPWR VGND sg13g2_nor2_1
X_8399_ _8399_/Y _8401_/A _9200_/Q _8399_/C VPWR VGND sg13g2_nand3_1
XFILLER_1_202 VPWR VGND sg13g2_fill_2
XFILLER_77_504 VPWR VGND sg13g2_decap_8
XFILLER_103_174 VPWR VGND sg13g2_decap_8
XFILLER_66_11 VPWR VGND sg13g2_fill_1
XFILLER_64_209 VPWR VGND sg13g2_fill_1
XFILLER_45_423 VPWR VGND sg13g2_decap_8
XFILLER_82_21 VPWR VGND sg13g2_decap_4
XFILLER_73_776 VPWR VGND sg13g2_fill_1
XFILLER_73_765 VPWR VGND sg13g2_decap_8
XFILLER_60_404 VPWR VGND sg13g2_fill_1
XFILLER_45_467 VPWR VGND sg13g2_decap_4
XFILLER_25_191 VPWR VGND sg13g2_fill_2
XFILLER_41_684 VPWR VGND sg13g2_decap_8
XFILLER_41_695 VPWR VGND sg13g2_fill_1
XFILLER_5_585 VPWR VGND sg13g2_decap_8
XFILLER_110_634 VPWR VGND sg13g2_fill_1
XFILLER_95_345 VPWR VGND sg13g2_fill_2
XFILLER_83_518 VPWR VGND sg13g2_decap_8
XFILLER_49_762 VPWR VGND sg13g2_fill_1
XFILLER_64_743 VPWR VGND sg13g2_decap_8
XFILLER_63_253 VPWR VGND sg13g2_decap_8
XFILLER_63_242 VPWR VGND sg13g2_fill_1
X_7770_ _7772_/C _8810_/Q _7824_/B _7846_/B1 _7770_/B2 VPWR VGND sg13g2_a22oi_1
XFILLER_63_297 VPWR VGND sg13g2_decap_8
X_4982_ _4983_/C _4928_/B _4903_/C _4903_/A VPWR VGND sg13g2_a21o_1
X_6721_ _9489_/D _9530_/Q _9489_/Q _6726_/S VPWR VGND sg13g2_mux2_1
XFILLER_16_191 VPWR VGND sg13g2_fill_1
X_9440_ _9440_/Q _9582_/CLK _9440_/D fanout983/X VPWR VGND sg13g2_dfrbpq_1
X_6652_ _6652_/Y _6642_/C _8649_/Q _9581_/Q _6655_/B2 VPWR VGND sg13g2_a22oi_1
XFILLER_82_0 VPWR VGND sg13g2_fill_2
X_9371_ _9371_/Q _9407_/CLK _9371_/D place2455/X VPWR VGND sg13g2_dfrbpq_1
X_5603_ _5603_/Y _5603_/A _5621_/B VPWR VGND sg13g2_nand2_1
X_6583_ _9426_/D _6670_/A1 _6582_/Y _6580_/Y VPWR VGND sg13g2_o21ai_1
X_8322_ _9161_/D _8350_/A1 _7925_/Y _8321_/Y VPWR VGND sg13g2_o21ai_1
X_5534_ _5534_/Y _5597_/A _5597_/B _8634_/Q _5597_/D VPWR VGND sg13g2_nand4_1
XFILLER_8_390 VPWR VGND sg13g2_fill_1
XFILLER_118_789 VPWR VGND sg13g2_fill_2
Xoutput2720 master_wdata_o[2] _5711_/X VPWR VGND sg13g2_buf_1
Xoutput2731 ndmreset_o _9253_/Q VPWR VGND sg13g2_buf_1
X_5465_ _5466_/A _5469_/A1 _8691_/Q _8692_/Q _5467_/B2 VPWR VGND sg13g2_a22oi_1
X_8253_ _8253_/Y _8253_/A _8285_/B VPWR VGND sg13g2_nand2_1
Xoutput2753 slave_rdata_o[29] _5007_/X VPWR VGND sg13g2_buf_1
Xoutput2742 slave_rdata_o[19] _4935_/Y VPWR VGND sg13g2_buf_1
X_8184_ _9092_/D _8190_/A1 _7909_/Y _8183_/Y VPWR VGND sg13g2_o21ai_1
Xoutput2764 slave_rid_o[0] _9411_/Q VPWR VGND sg13g2_buf_1
X_4416_ _6333_/B _9224_/Q _4416_/B _4416_/C VPWR VGND sg13g2_nand3b_1
X_7204_ _7204_/Y _7204_/A _7207_/B _7207_/C _7221_/D VPWR VGND sg13g2_nand4_1
X_5396_ _5401_/A _5400_/A _5400_/C _7028_/B VPWR VGND sg13g2_a21o_1
X_7135_ _7135_/Y _7156_/A _8864_/Q VPWR VGND sg13g2_nand2_1
X_4347_ _4347_/Y _9650_/Q _4347_/B VPWR VGND sg13g2_nor2_1
XFILLER_59_515 VPWR VGND sg13g2_decap_8
X_9494__2886 _9494_/RESET_B VPWR VGND sg13g2_tiehi
XFILLER_59_548 VPWR VGND sg13g2_decap_8
X_7066_ _7066_/Y _5353_/C _6967_/Y _7065_/Y VPWR VGND sg13g2_o21ai_1
XFILLER_74_507 VPWR VGND sg13g2_fill_2
X_6017_ _6019_/A _6064_/A _6064_/B _6047_/A VPWR VGND sg13g2_nand3_1
XFILLER_27_412 VPWR VGND sg13g2_decap_8
XFILLER_39_272 VPWR VGND sg13g2_decap_8
XFILLER_82_595 VPWR VGND sg13g2_decap_4
XFILLER_70_746 VPWR VGND sg13g2_decap_8
XFILLER_54_286 VPWR VGND sg13g2_fill_1
X_7968_ _8994_/D _5348_/C _7969_/A _7967_/Y VPWR VGND sg13g2_o21ai_1
XFILLER_70_768 VPWR VGND sg13g2_decap_8
X_7899_ _7899_/Y _7899_/A _8964_/Q _8361_/C VPWR VGND sg13g2_nand3_1
X_9707_ _9707_/Q _9708_/CLK _9707_/D fanout954/X VPWR VGND sg13g2_dfrbpq_1
X_6919_ _9624_/D _9624_/Q _6915_/B _6918_/X VPWR VGND sg13g2_a21o_1
X_9638_ _9638_/Q _9649_/CLK _9638_/D fanout974/X VPWR VGND sg13g2_dfrbpq_1
XFILLER_11_802 VPWR VGND sg13g2_fill_2
X_9569_ _9569_/Q _9588_/CLK _9569_/D _9569_/RESET_B VPWR VGND sg13g2_dfrbpq_1
Xclkbuf_1_0__f_i_dmi_jtag.i_dmi_jtag_tap.i_dft_tck_mux.clk_o _8664_/CLK clkbuf_0_i_dmi_jtag.i_dmi_jtag_tap.i_dft_tck_mux.clk_o/X
+ VPWR VGND sg13g2_buf_8
XFILLER_6_349 VPWR VGND sg13g2_fill_1
XFILLER_109_778 VPWR VGND sg13g2_decap_8
XFILLER_2_544 VPWR VGND sg13g2_decap_8
XFILLER_77_43 VPWR VGND sg13g2_decap_8
XFILLER_77_345 VPWR VGND sg13g2_fill_2
XFILLER_92_326 VPWR VGND sg13g2_fill_2
XFILLER_45_220 VPWR VGND sg13g2_fill_2
XFILLER_61_746 VPWR VGND sg13g2_fill_1
XFILLER_61_735 VPWR VGND sg13g2_decap_8
XFILLER_45_275 VPWR VGND sg13g2_fill_1
XFILLER_45_297 VPWR VGND sg13g2_fill_2
XFILLER_61_779 VPWR VGND sg13g2_fill_2
XFILLER_60_234 VPWR VGND sg13g2_fill_1
XFILLER_26_80 VPWR VGND sg13g2_fill_1
XFILLER_33_459 VPWR VGND sg13g2_fill_1
XFILLER_9_110 VPWR VGND sg13g2_decap_4
XFILLER_41_470 VPWR VGND sg13g2_decap_8
X_5250_ _5250_/Y _9875_/A _5242_/Y _5249_/Y VPWR VGND sg13g2_o21ai_1
XFILLER_5_382 VPWR VGND sg13g2_fill_1
X_5181_ _5181_/Y _5181_/A _5181_/B VPWR VGND sg13g2_nand2_1
XFILLER_3_73 VPWR VGND sg13g2_decap_8
X_8940_ _8940_/Q _9611_/CLK _8940_/D place2412/X VPWR VGND sg13g2_dfrbpq_1
XFILLER_96_687 VPWR VGND sg13g2_fill_2
XFILLER_68_389 VPWR VGND sg13g2_decap_4
XFILLER_28_209 VPWR VGND sg13g2_fill_1
XFILLER_83_337 VPWR VGND sg13g2_fill_1
XFILLER_64_562 VPWR VGND sg13g2_decap_8
X_8871_ _8871_/Q _9692_/CLK _8871_/D place2493/X VPWR VGND sg13g2_dfrbpq_1
XFILLER_37_765 VPWR VGND sg13g2_decap_8
X_9479__2901 _9479_/RESET_B VPWR VGND sg13g2_tiehi
X_7822_ _7822_/Y _7822_/A _7822_/B _7822_/C _7822_/D VPWR VGND sg13g2_nor4_1
X_7753_ _7754_/D _7753_/A _7753_/B _7753_/C _7753_/D VPWR VGND sg13g2_and4_1
XFILLER_91_392 VPWR VGND sg13g2_fill_2
X_4965_ _4965_/Y _4814_/B _4945_/C _4959_/C VPWR VGND sg13g2_a21oi_1
Xinput2607 _5891_/B1 master_rdata_i[7] VPWR VGND sg13g2_buf_1
X_6704_ _9472_/D _9513_/Q _9472_/Q _6710_/S VPWR VGND sg13g2_mux2_1
XFILLER_51_289 VPWR VGND sg13g2_fill_1
XFILLER_51_278 VPWR VGND sg13g2_fill_2
XFILLER_51_267 VPWR VGND sg13g2_fill_1
X_7684_ _7687_/C _7690_/A _7741_/B _8981_/Q VPWR VGND sg13g2_nor3_1
X_9423_ _9423_/Q _9587_/CLK _9423_/D fanout978/X VPWR VGND sg13g2_dfrbpq_1
Xinput2618 _6536_/A1 slave_aid_i[0] VPWR VGND sg13g2_buf_1
XFILLER_20_643 VPWR VGND sg13g2_decap_4
X_4896_ _4896_/Y _4893_/Y _4895_/X _4853_/A VPWR VGND sg13g2_a21oi_1
Xinput2629 _7182_/B slave_wdata_i[15] VPWR VGND sg13g2_buf_1
X_6635_ _6635_/X _6661_/A _9576_/Q _6642_/C VPWR VGND sg13g2_or3_1
XFILLER_118_531 VPWR VGND sg13g2_decap_8
X_6566_ _6566_/Y _6566_/A _6948_/B _9588_/Q _6566_/D VPWR VGND sg13g2_nor4_1
X_9354_ _9354_/Q clkload9/A _9354_/D place2504/X VPWR VGND sg13g2_dfrbpq_1
X_9285_ _9285_/Q _9304_/CLK _9285_/D place2410/X VPWR VGND sg13g2_dfrbpq_1
X_5517_ _5517_/Y _9425_/Q _5615_/B _5523_/B1 _8627_/Q VPWR VGND sg13g2_a22oi_1
X_8305_ _8305_/Y _8305_/A _8349_/B VPWR VGND sg13g2_nand2_1
XFILLER_106_748 VPWR VGND sg13g2_decap_8
X_6497_ _6497_/Y _6504_/A1 _6312_/A _6497_/B1 VPWR VGND sg13g2_a21oi_1
X_8236_ _9118_/D _8244_/A1 _7897_/Y _8235_/Y VPWR VGND sg13g2_o21ai_1
X_5448_ _8682_/D _5448_/A _5454_/B_N VPWR VGND sg13g2_nor2b_1
XFILLER_120_206 VPWR VGND sg13g2_decap_4
X_5379_ _5379_/X _5376_/Y _5378_/Y _8750_/Q VPWR VGND sg13g2_a21o_1
X_8167_ _8167_/Y _8167_/A _8191_/B VPWR VGND sg13g2_nand2_1
XFILLER_101_431 VPWR VGND sg13g2_fill_2
XFILLER_87_632 VPWR VGND sg13g2_fill_1
XFILLER_86_131 VPWR VGND sg13g2_decap_4
X_8098_ _9049_/D _8098_/A1 _7951_/Y _8097_/Y VPWR VGND sg13g2_o21ai_1
X_7118_ _7118_/Y _8439_/A2 _7130_/A2 _7117_/Y VPWR VGND sg13g2_o21ai_1
XFILLER_87_676 VPWR VGND sg13g2_decap_8
X_7049_ _7049_/Y _7897_/D _6966_/Y _7036_/X _4435_/B VPWR VGND sg13g2_a22oi_1
XFILLER_103_63 VPWR VGND sg13g2_decap_8
XFILLER_42_201 VPWR VGND sg13g2_fill_2
XFILLER_42_212 VPWR VGND sg13g2_decap_8
XFILLER_63_34 VPWR VGND sg13g2_decap_8
XFILLER_70_565 VPWR VGND sg13g2_fill_2
XFILLER_63_89 VPWR VGND sg13g2_fill_1
XFILLER_42_267 VPWR VGND sg13g2_decap_8
XFILLER_42_278 VPWR VGND sg13g2_decap_8
XFILLER_11_632 VPWR VGND sg13g2_fill_2
XFILLER_11_621 VPWR VGND sg13g2_decap_8
XFILLER_23_470 VPWR VGND sg13g2_fill_1
XFILLER_109_520 VPWR VGND sg13g2_fill_2
XFILLER_11_687 VPWR VGND sg13g2_decap_8
XFILLER_6_146 VPWR VGND sg13g2_decap_8
XFILLER_88_97 VPWR VGND sg13g2_decap_8
XFILLER_93_635 VPWR VGND sg13g2_decap_8
XFILLER_93_624 VPWR VGND sg13g2_decap_4
XFILLER_19_743 VPWR VGND sg13g2_fill_2
XFILLER_34_702 VPWR VGND sg13g2_decap_8
X_9598__2792 _9598_/RESET_B VPWR VGND sg13g2_tiehi
XFILLER_92_178 VPWR VGND sg13g2_decap_4
XFILLER_18_264 VPWR VGND sg13g2_decap_8
XFILLER_19_798 VPWR VGND sg13g2_decap_8
XFILLER_34_713 VPWR VGND sg13g2_fill_2
X_4750_ _4983_/A _4750_/A _4750_/B VPWR VGND sg13g2_nand2_1
X_4681_ _9661_/D _8743_/Q _4681_/B VPWR VGND sg13g2_nor2_1
X_6420_ _9391_/D _6505_/A2 _6418_/Y _6419_/Y VPWR VGND sg13g2_a21oi_1
Xplace2504 place2504/X place2505/X VPWR VGND sg13g2_buf_1
XFILLER_115_501 VPWR VGND sg13g2_decap_8
Xplace1803 _5336_/B2 _5288_/B2 VPWR VGND sg13g2_buf_1
Xplace2526 _6363_/S1 _6349_/S1 VPWR VGND sg13g2_buf_1
X_6351_ _6351_/Y _6348_/Y _6350_/Y _6392_/S VPWR VGND sg13g2_a21oi_1
Xplace2515 _6381_/S0 _6061_/A VPWR VGND sg13g2_buf_1
Xplace2537 _7207_/B _7187_/D VPWR VGND sg13g2_buf_1
X_5302_ _8777_/D _5341_/A1 _5297_/Y _5301_/Y _5336_/B2 VPWR VGND sg13g2_a22oi_1
Xplace1814 _8355_/A _8409_/A VPWR VGND sg13g2_buf_1
Xplace1836 _7969_/A _8007_/A VPWR VGND sg13g2_buf_1
Xplace1825 _8101_/B _8055_/B VPWR VGND sg13g2_buf_1
Xplace1858 _5963_/B _5960_/B VPWR VGND sg13g2_buf_1
Xplace1847 _6906_/S _6904_/S VPWR VGND sg13g2_buf_1
X_9070_ _9070_/Q clkload6/A _9070_/D place2434/X VPWR VGND sg13g2_dfrbpq_1
X_6282_ _6475_/A _9235_/Q _6322_/B VPWR VGND sg13g2_nand2b_1
Xplace1869 _8470_/A _8458_/A VPWR VGND sg13g2_buf_1
Xhold3206 _8303_/A _9152_/Q VPWR VGND sg13g2_dlygate4sd3_1
XFILLER_45_0 VPWR VGND sg13g2_decap_8
Xhold3228 _8141_/A _9071_/Q VPWR VGND sg13g2_dlygate4sd3_1
Xhold3217 _7950_/B _8987_/Q VPWR VGND sg13g2_dlygate4sd3_1
X_5233_ _5233_/Y _5233_/A _9873_/A VPWR VGND sg13g2_nand2_1
X_8021_ _8021_/Y _8021_/A _8052_/B VPWR VGND sg13g2_nand2_1
Xhold3239 _5671_/A1 _8590_/Q VPWR VGND sg13g2_dlygate4sd3_1
XFILLER_102_239 VPWR VGND sg13g2_decap_4
X_5164_ _5164_/Y _5187_/A _5178_/B _5187_/D _5178_/A VPWR VGND sg13g2_nand4_1
XFILLER_68_120 VPWR VGND sg13g2_decap_4
X_5095_ _5158_/D _5187_/A _8517_/B VPWR VGND sg13g2_nor2_1
XFILLER_83_101 VPWR VGND sg13g2_decap_8
XFILLER_56_326 VPWR VGND sg13g2_fill_2
X_8923_ _8923_/Q _9611_/CLK _8923_/D place2414/X VPWR VGND sg13g2_dfrbpq_1
X_8854_ _8854_/Q _9407_/CLK _8854_/D place2455/X VPWR VGND sg13g2_dfrbpq_1
X_7805_ _7806_/D _9173_/Q _7782_/B _7801_/A VPWR VGND sg13g2_o21ai_1
XFILLER_24_245 VPWR VGND sg13g2_fill_2
XFILLER_25_757 VPWR VGND sg13g2_decap_8
X_5997_ _9334_/D _5996_/Y _9334_/Q _6006_/S VPWR VGND sg13g2_mux2_1
X_8785_ _8785_/Q _9254_/CLK _8785_/D place2423/X VPWR VGND sg13g2_dfrbpq_1
X_7736_ _8920_/D _8920_/Q _7735_/Y _7812_/S VPWR VGND sg13g2_mux2_1
X_4948_ _4948_/Y _4903_/A _4816_/B _4826_/Y VPWR VGND sg13g2_o21ai_1
XFILLER_40_738 VPWR VGND sg13g2_decap_8
X_4879_ _4880_/C _4823_/B _4827_/B _4768_/C _4903_/D VPWR VGND sg13g2_a22oi_1
X_7667_ _7667_/Y _7667_/A _7667_/B _7667_/C _7667_/D VPWR VGND sg13g2_nor4_1
XFILLER_123_7 VPWR VGND sg13g2_decap_8
X_6618_ _6618_/X _6661_/A _9571_/Q _6622_/C VPWR VGND sg13g2_or3_1
X_9406_ _9406_/Q _9406_/CLK _9406_/D place2489/X VPWR VGND sg13g2_dfrbpq_1
X_7598_ _7600_/A _8851_/Q _7598_/A2 _7598_/B1 _8882_/Q VPWR VGND sg13g2_a22oi_1
X_9337_ _9337_/Q _9409_/CLK _9337_/D place2399/X VPWR VGND sg13g2_dfrbpq_1
XFILLER_4_628 VPWR VGND sg13g2_decap_8
XFILLER_3_116 VPWR VGND sg13g2_decap_4
X_6549_ _9416_/D _8657_/Q _6544_/Y _6548_/X VPWR VGND sg13g2_a21o_1
X_9268_ _9268_/Q _9305_/CLK _9268_/D place2419/X VPWR VGND sg13g2_dfrbpq_1
X_9199_ _9199_/Q _9199_/CLK _9199_/D place2423/X VPWR VGND sg13g2_dfrbpq_1
X_8219_ _8219_/Y _8219_/A _8219_/B VPWR VGND sg13g2_nand2_1
XFILLER_101_272 VPWR VGND sg13g2_fill_1
XFILLER_101_261 VPWR VGND sg13g2_fill_1
XFILLER_47_337 VPWR VGND sg13g2_fill_1
XFILLER_15_212 VPWR VGND sg13g2_fill_1
XFILLER_43_532 VPWR VGND sg13g2_fill_2
XFILLER_70_362 VPWR VGND sg13g2_fill_2
XFILLER_43_576 VPWR VGND sg13g2_decap_8
XFILLER_11_462 VPWR VGND sg13g2_decap_8
XFILLER_7_466 VPWR VGND sg13g2_fill_1
XFILLER_99_96 VPWR VGND sg13g2_decap_8
XFILLER_112_537 VPWR VGND sg13g2_decap_8
XFILLER_3_694 VPWR VGND sg13g2_decap_8
XFILLER_93_443 VPWR VGND sg13g2_decap_8
XFILLER_65_156 VPWR VGND sg13g2_fill_2
XFILLER_65_145 VPWR VGND sg13g2_decap_8
XFILLER_65_134 VPWR VGND sg13g2_decap_8
X_5920_ _5920_/Y _9317_/Q _5920_/B VPWR VGND sg13g2_nand2_1
XFILLER_93_487 VPWR VGND sg13g2_decap_8
XFILLER_80_104 VPWR VGND sg13g2_fill_2
XFILLER_0_63 VPWR VGND sg13g2_decap_8
XFILLER_34_521 VPWR VGND sg13g2_decap_4
XFILLER_34_543 VPWR VGND sg13g2_fill_1
X_5851_ _5851_/Y _5930_/A1 _5906_/A2 _5851_/B1 _5952_/A VPWR VGND sg13g2_a22oi_1
XFILLER_34_554 VPWR VGND sg13g2_decap_8
X_8570_ _9277_/D _5856_/Y _8563_/X _8569_/Y VPWR VGND sg13g2_o21ai_1
X_5782_ _5787_/C _5837_/A2 _8426_/C VPWR VGND sg13g2_nand2b_1
XFILLER_61_373 VPWR VGND sg13g2_decap_4
X_4802_ _4802_/Y _9380_/Q _4770_/Y _4796_/Y VPWR VGND sg13g2_a21oi_1
XFILLER_119_103 VPWR VGND sg13g2_decap_4
X_4733_ _9683_/D _4733_/A VPWR VGND sg13g2_inv_1
X_7521_ _7525_/D _9159_/Q _7816_/B _7667_/A VPWR VGND sg13g2_o21ai_1
X_7452_ _7453_/D _9031_/Q _7491_/B _7450_/X VPWR VGND sg13g2_o21ai_1
Xplace2312 _5110_/A _9260_/Q VPWR VGND sg13g2_buf_1
X_4664_ _4665_/B _9642_/Q _8718_/Q VPWR VGND sg13g2_nor2b_1
X_6403_ _9388_/D _6401_/Y _6056_/Y _6402_/Y VPWR VGND sg13g2_a21oi_1
Xplace2301 _4898_/C _4814_/B VPWR VGND sg13g2_buf_1
X_4595_ _6519_/B _9410_/Q _9408_/Q VPWR VGND sg13g2_nor2_1
Xplace2345 _5890_/B _5735_/B VPWR VGND sg13g2_buf_1
Xplace2356 _8389_/C _8432_/C VPWR VGND sg13g2_buf_1
Xplace2323 _8474_/B _6247_/C VPWR VGND sg13g2_buf_1
X_7383_ _7384_/C _7404_/C _9121_/Q _7387_/C VPWR VGND sg13g2_nor3_1
Xplace2334 _4783_/B _4957_/D VPWR VGND sg13g2_buf_1
X_6334_ _6334_/Y _8821_/Q _6462_/A2 _6331_/X _6515_/B1 _6333_/Y VPWR VGND sg13g2_a221oi_1
Xplace2378 _8474_/C _8355_/C VPWR VGND sg13g2_buf_1
Xplace2389 _7237_/B1 _4452_/B VPWR VGND sg13g2_buf_1
Xplace2367 _8361_/C _8056_/A VPWR VGND sg13g2_buf_1
X_9122_ _9122_/Q _9183_/CLK _9122_/D place2470/X VPWR VGND sg13g2_dfrbpq_1
Xhold3014 hold3014/X _8706_/Q VPWR VGND sg13g2_dlygate4sd3_1
XFILLER_103_515 VPWR VGND sg13g2_fill_2
XFILLER_89_727 VPWR VGND sg13g2_decap_8
Xhold3003 _8111_/A _9056_/Q VPWR VGND sg13g2_dlygate4sd3_1
X_9053_ _9053_/Q clkload5/A _9053_/D place2499/X VPWR VGND sg13g2_dfrbpq_1
XFILLER_0_108 VPWR VGND sg13g2_decap_8
X_6265_ _6265_/Y _6265_/A _6265_/B _6265_/C VPWR VGND sg13g2_nand3_1
Xhold3047 _8137_/A _9069_/Q VPWR VGND sg13g2_dlygate4sd3_1
Xhold3025 _6671_/A _9453_/Q VPWR VGND sg13g2_dlygate4sd3_1
Xhold3036 _8079_/A _9043_/Q VPWR VGND sg13g2_dlygate4sd3_1
X_8004_ _9012_/D _5275_/Y _8003_/A _8003_/Y VPWR VGND sg13g2_o21ai_1
X_5216_ _5216_/Y _5215_/A _5223_/B _5238_/A VPWR VGND sg13g2_a21oi_1
Xhold3069 _6606_/A _9434_/Q VPWR VGND sg13g2_dlygate4sd3_1
Xhold3058 _8221_/A _9111_/Q VPWR VGND sg13g2_dlygate4sd3_1
XFILLER_69_462 VPWR VGND sg13g2_fill_2
XFILLER_69_451 VPWR VGND sg13g2_fill_1
X_6196_ _6196_/Y _8846_/Q _6411_/A2 _6194_/X _6401_/B2 _6319_/C1 VPWR VGND sg13g2_a221oi_1
XFILLER_111_570 VPWR VGND sg13g2_decap_8
XFILLER_97_782 VPWR VGND sg13g2_fill_2
X_5147_ _5150_/B _5175_/B _5147_/B _5175_/C _5147_/D VPWR VGND sg13g2_nand4_1
XFILLER_29_304 VPWR VGND sg13g2_fill_2
XFILLER_96_292 VPWR VGND sg13g2_decap_8
XFILLER_84_465 VPWR VGND sg13g2_decap_8
XFILLER_72_605 VPWR VGND sg13g2_fill_2
X_5078_ _5344_/C _9471_/Q _8061_/A VPWR VGND sg13g2_nand2_1
XFILLER_57_679 VPWR VGND sg13g2_fill_2
XFILLER_56_134 VPWR VGND sg13g2_fill_1
XFILLER_29_348 VPWR VGND sg13g2_decap_8
X_8906_ _8906_/Q _9504_/CLK _8906_/D place2429/X VPWR VGND sg13g2_dfrbpq_1
XFILLER_25_510 VPWR VGND sg13g2_fill_1
X_9886_ _9886_/X _9886_/A VPWR VGND sg13g2_buf_1
XFILLER_72_649 VPWR VGND sg13g2_decap_8
XFILLER_71_137 VPWR VGND sg13g2_decap_8
XFILLER_71_126 VPWR VGND sg13g2_decap_4
XFILLER_80_671 VPWR VGND sg13g2_decap_8
X_8837_ _8837_/Q _9692_/CLK _8837_/D place2496/X VPWR VGND sg13g2_dfrbpq_1
XFILLER_13_705 VPWR VGND sg13g2_fill_1
XFILLER_25_554 VPWR VGND sg13g2_decap_8
X_8768_ _9874_/A _9260_/CLK _8768_/D place2391/X VPWR VGND sg13g2_dfrbpq_1
XFILLER_13_727 VPWR VGND sg13g2_decap_8
XFILLER_13_749 VPWR VGND sg13g2_decap_8
XFILLER_44_69 VPWR VGND sg13g2_fill_1
XFILLER_100_53 VPWR VGND sg13g2_decap_8
X_7719_ _7722_/C _9045_/Q _7719_/B VPWR VGND sg13g2_nor2_1
X_8699_ _8699_/Q _9649_/CLK _8699_/D fanout977/X VPWR VGND sg13g2_dfrbpq_1
XFILLER_60_68 VPWR VGND sg13g2_decap_8
XFILLER_4_425 VPWR VGND sg13g2_decap_8
XFILLER_106_331 VPWR VGND sg13g2_fill_2
XFILLER_106_397 VPWR VGND sg13g2_fill_2
XFILLER_48_602 VPWR VGND sg13g2_decap_4
XFILLER_48_624 VPWR VGND sg13g2_decap_4
XFILLER_85_54 VPWR VGND sg13g2_decap_8
XFILLER_48_657 VPWR VGND sg13g2_fill_2
XFILLER_90_413 VPWR VGND sg13g2_decap_8
XFILLER_85_98 VPWR VGND sg13g2_fill_2
XFILLER_63_616 VPWR VGND sg13g2_fill_2
XFILLER_62_137 VPWR VGND sg13g2_decap_8
XFILLER_16_510 VPWR VGND sg13g2_fill_1
XFILLER_18_92 VPWR VGND sg13g2_decap_8
XFILLER_71_660 VPWR VGND sg13g2_fill_2
XFILLER_43_351 VPWR VGND sg13g2_decap_4
XFILLER_71_693 VPWR VGND sg13g2_fill_2
XFILLER_71_682 VPWR VGND sg13g2_decap_8
XFILLER_31_524 VPWR VGND sg13g2_decap_8
XFILLER_11_281 VPWR VGND sg13g2_fill_1
XFILLER_7_263 VPWR VGND sg13g2_fill_2
X_4380_ _9641_/D _9639_/Q _4378_/B _4379_/Y VPWR VGND sg13g2_o21ai_1
XFILLER_7_296 VPWR VGND sg13g2_fill_2
XFILLER_112_312 VPWR VGND sg13g2_fill_2
XFILLER_98_557 VPWR VGND sg13g2_fill_1
X_6050_ _6275_/B _6309_/B _6958_/C VPWR VGND sg13g2_nor2_1
X_5001_ _5001_/Y _9404_/Q _4934_/B _5000_/Y VPWR VGND sg13g2_a21oi_1
XFILLER_38_112 VPWR VGND sg13g2_fill_2
XFILLER_94_741 VPWR VGND sg13g2_fill_2
XFILLER_93_262 VPWR VGND sg13g2_decap_8
XFILLER_53_104 VPWR VGND sg13g2_decap_8
XFILLER_26_318 VPWR VGND sg13g2_decap_8
X_6952_ _9635_/D _6566_/A _6951_/Y _6952_/S VPWR VGND sg13g2_mux2_1
X_6883_ _6883_/X _8915_/Q _8947_/Q _6901_/S VPWR VGND sg13g2_mux2_1
X_5903_ _9314_/D _5902_/Y _5935_/A2 _5896_/Y VPWR VGND sg13g2_o21ai_1
X_9671_ _9671_/Q _9675_/CLK _9671_/D place2443/X VPWR VGND sg13g2_dfrbpq_1
X_5834_ _5834_/Y _5939_/A _5831_/X _5925_/C VPWR VGND sg13g2_o21ai_1
X_8622_ _8622_/Q _9689_/CLK _8622_/D fanout959/X VPWR VGND sg13g2_dfrbpq_1
X_5765_ _5765_/Y _9328_/Q _5765_/B VPWR VGND sg13g2_nand2b_1
X_8553_ _9269_/D _8553_/A VPWR VGND sg13g2_inv_1
XFILLER_10_719 VPWR VGND sg13g2_fill_1
XFILLER_108_607 VPWR VGND sg13g2_decap_8
X_4716_ _9677_/D _8737_/Q _9677_/Q _6802_/S VPWR VGND sg13g2_a21o_1
X_5696_ _8601_/D _5696_/A VPWR VGND sg13g2_inv_1
X_7504_ _7506_/A _7819_/C _7819_/B _9096_/Q VPWR VGND sg13g2_nor3_1
X_8484_ _8484_/Y _8486_/A _9247_/Q _8492_/C VPWR VGND sg13g2_nand3_1
X_4647_ _8739_/D _4647_/A _4647_/B _4647_/C VPWR VGND sg13g2_nand3_1
Xplace2120 _8156_/A1 _8160_/A1 VPWR VGND sg13g2_buf_1
X_7435_ _7437_/B _8793_/Q _7301_/B _7269_/X _4521_/Y VPWR VGND sg13g2_a22oi_1
Xplace2131 _8489_/A2 _5364_/C VPWR VGND sg13g2_buf_1
Xplace2142 _5771_/B1 _5763_/B1 VPWR VGND sg13g2_buf_1
Xplace2164 _6153_/D _6190_/D VPWR VGND sg13g2_buf_1
X_7366_ _7366_/Y _7366_/A _7366_/B _7366_/C _7366_/D VPWR VGND sg13g2_nor4_1
Xplace2153 _4903_/D _4842_/B VPWR VGND sg13g2_buf_1
XFILLER_30_49 VPWR VGND sg13g2_fill_1
XFILLER_116_673 VPWR VGND sg13g2_decap_8
XFILLER_104_802 VPWR VGND sg13g2_fill_2
Xplace2186 _7735_/B _7811_/B VPWR VGND sg13g2_buf_1
XFILLER_89_502 VPWR VGND sg13g2_decap_8
X_9105_ _9105_/Q _9620_/CLK _9105_/D place2439/X VPWR VGND sg13g2_dfrbpq_1
Xplace2175 _6566_/D _6951_/A VPWR VGND sg13g2_buf_1
XFILLER_1_417 VPWR VGND sg13g2_fill_2
X_4578_ _9703_/D _4590_/B _4743_/A VPWR VGND sg13g2_nor2b_1
X_6317_ _6317_/Y _6325_/A1 _6316_/Y _6229_/B VPWR VGND sg13g2_o21ai_1
Xplace2197 _5625_/B _9695_/Q VPWR VGND sg13g2_buf_1
X_7297_ _7299_/C _7425_/C _7297_/B _8961_/Q VPWR VGND sg13g2_nor3_1
XFILLER_89_579 VPWR VGND sg13g2_decap_8
X_9036_ _9036_/Q _9254_/CLK _9036_/D place2427/X VPWR VGND sg13g2_dfrbpq_1
X_6248_ _6249_/C _9232_/Q _6509_/D _6248_/C _6516_/C VPWR VGND sg13g2_and4_1
XFILLER_85_730 VPWR VGND sg13g2_decap_8
X_6179_ _6181_/A _6510_/B _6438_/A _6188_/A VPWR VGND sg13g2_o21ai_1
XFILLER_29_112 VPWR VGND sg13g2_decap_4
XFILLER_18_808 VPWR VGND sg13g2_fill_1
XFILLER_84_295 VPWR VGND sg13g2_decap_8
XFILLER_111_30 VPWR VGND sg13g2_fill_1
X_9869_ _9869_/X _9869_/A VPWR VGND sg13g2_buf_1
XFILLER_60_619 VPWR VGND sg13g2_decap_8
XFILLER_25_351 VPWR VGND sg13g2_fill_1
XFILLER_25_373 VPWR VGND sg13g2_decap_4
XFILLER_9_517 VPWR VGND sg13g2_decap_8
XFILLER_40_354 VPWR VGND sg13g2_decap_8
XFILLER_4_266 VPWR VGND sg13g2_decap_8
XFILLER_106_183 VPWR VGND sg13g2_fill_1
XFILLER_96_64 VPWR VGND sg13g2_fill_2
XFILLER_76_774 VPWR VGND sg13g2_decap_8
XFILLER_29_91 VPWR VGND sg13g2_decap_8
XFILLER_91_733 VPWR VGND sg13g2_decap_8
XFILLER_90_232 VPWR VGND sg13g2_fill_2
XFILLER_91_766 VPWR VGND sg13g2_decap_8
XFILLER_44_682 VPWR VGND sg13g2_decap_4
X_5550_ _5550_/Y _8639_/Q _5592_/A2 _5589_/B1 _8638_/Q VPWR VGND sg13g2_a22oi_1
X_4501_ _4504_/B _8704_/Q _9463_/Q VPWR VGND sg13g2_nor2_1
X_5481_ _6951_/C _9635_/Q _9633_/Q VPWR VGND sg13g2_nand2b_1
XFILLER_8_572 VPWR VGND sg13g2_decap_8
X_4432_ _5394_/B _6309_/A _4432_/B VPWR VGND sg13g2_nor2_1
X_7220_ _8889_/D _7219_/Y _8889_/Q _7239_/S VPWR VGND sg13g2_mux2_1
XFILLER_98_310 VPWR VGND sg13g2_decap_4
X_4363_ _4598_/B _9669_/Q _4363_/B VPWR VGND sg13g2_nand2_1
X_7151_ _8869_/D _6975_/X _7149_/Y _7150_/Y VPWR VGND sg13g2_o21ai_1
X_6102_ _6438_/D _6369_/A _6369_/B _6369_/D VPWR VGND sg13g2_nand3_1
X_4294_ _7132_/A _7187_/A VPWR VGND sg13g2_inv_1
X_7082_ _8847_/D _7081_/Y _8847_/Q _7085_/S VPWR VGND sg13g2_mux2_1
X_6033_ _6365_/A _6046_/D _6033_/B _6033_/C _6033_/D VPWR VGND sg13g2_nor4_1
XFILLER_39_410 VPWR VGND sg13g2_decap_8
XFILLER_79_590 VPWR VGND sg13g2_fill_1
XFILLER_67_785 VPWR VGND sg13g2_fill_1
XFILLER_54_402 VPWR VGND sg13g2_fill_1
XFILLER_39_454 VPWR VGND sg13g2_fill_1
XFILLER_94_582 VPWR VGND sg13g2_decap_8
X_7984_ _9002_/D _5356_/C _7985_/A _7983_/Y VPWR VGND sg13g2_o21ai_1
XFILLER_81_243 VPWR VGND sg13g2_decap_8
X_6935_ _6935_/Y _9630_/Q _6937_/B _6939_/C VPWR VGND sg13g2_nand3_1
XFILLER_34_170 VPWR VGND sg13g2_decap_8
X_9654_ _9654_/Q _9662_/CLK _9654_/D place2447/X VPWR VGND sg13g2_dfrbpq_1
X_6866_ _9599_/D _6865_/X _9599_/Q _6904_/S VPWR VGND sg13g2_mux2_1
X_9585_ _9585_/Q _9587_/CLK _9585_/D _9585_/RESET_B VPWR VGND sg13g2_dfrbpq_1
X_5817_ _9301_/D _5817_/A VPWR VGND sg13g2_inv_1
X_6797_ _6797_/Y _9684_/Q _9689_/Q _9687_/Q _9686_/Q VPWR VGND sg13g2_nor4_1
XFILLER_10_505 VPWR VGND sg13g2_decap_4
X_8605_ _8605_/Q _9708_/CLK _8605_/D fanout961/X VPWR VGND sg13g2_dfrbpq_1
X_5748_ _5748_/Y _5772_/A1 _5746_/Y _5747_/Y VPWR VGND sg13g2_a21oi_1
X_8536_ _8536_/Y _8536_/A _8536_/B VPWR VGND sg13g2_nor2_1
XFILLER_10_549 VPWR VGND sg13g2_decap_4
XFILLER_41_48 VPWR VGND sg13g2_fill_1
XFILLER_108_426 VPWR VGND sg13g2_fill_2
XFILLER_108_415 VPWR VGND sg13g2_fill_1
XFILLER_108_448 VPWR VGND sg13g2_decap_8
X_5679_ _5679_/Y _8594_/Q _5693_/A2 _5693_/B1 _5679_/B2 VPWR VGND sg13g2_a22oi_1
X_8467_ _9238_/D _8476_/A _5352_/C _8466_/Y VPWR VGND sg13g2_o21ai_1
X_7418_ _8904_/D _7417_/Y _7576_/S _7398_/Y VPWR VGND sg13g2_a21oi_1
X_8398_ _9199_/D _5367_/C _8397_/A _8397_/Y VPWR VGND sg13g2_o21ai_1
XFILLER_89_310 VPWR VGND sg13g2_decap_4
X_7349_ _7353_/B _7351_/C _8995_/Q _7387_/C VPWR VGND sg13g2_nor3_1
XFILLER_104_665 VPWR VGND sg13g2_decap_8
XFILLER_89_343 VPWR VGND sg13g2_fill_2
XFILLER_89_398 VPWR VGND sg13g2_decap_4
X_9019_ _9019_/Q _9251_/CLK _9019_/D place2461/X VPWR VGND sg13g2_dfrbpq_1
XFILLER_92_508 VPWR VGND sg13g2_decap_4
XFILLER_73_700 VPWR VGND sg13g2_decap_4
XFILLER_66_67 VPWR VGND sg13g2_fill_1
XFILLER_18_616 VPWR VGND sg13g2_fill_1
XFILLER_17_159 VPWR VGND sg13g2_fill_1
XFILLER_82_44 VPWR VGND sg13g2_decap_8
XFILLER_60_427 VPWR VGND sg13g2_fill_2
XFILLER_60_449 VPWR VGND sg13g2_decap_8
XFILLER_13_310 VPWR VGND sg13g2_fill_1
XFILLER_41_630 VPWR VGND sg13g2_decap_8
XFILLER_41_641 VPWR VGND sg13g2_decap_8
XFILLER_13_365 VPWR VGND sg13g2_decap_8
XFILLER_99_107 VPWR VGND sg13g2_fill_1
XFILLER_99_118 VPWR VGND sg13g2_decap_8
XFILLER_49_7 VPWR VGND sg13g2_decap_8
XFILLER_64_700 VPWR VGND sg13g2_fill_2
XFILLER_23_118 VPWR VGND sg13g2_fill_1
X_4981_ _4981_/Y _4944_/A _9370_/Q VPWR VGND sg13g2_nand2b_1
X_6720_ _9488_/D _9529_/Q _9488_/Q _6726_/S VPWR VGND sg13g2_mux2_1
XFILLER_16_170 VPWR VGND sg13g2_fill_2
XFILLER_32_630 VPWR VGND sg13g2_decap_8
XFILLER_32_641 VPWR VGND sg13g2_fill_1
X_6651_ _6651_/Y _9447_/Q _6651_/B VPWR VGND sg13g2_nand2_1
XFILLER_32_685 VPWR VGND sg13g2_decap_8
X_5602_ _8655_/D _5601_/Y _5600_/Y _5602_/B1 VPWR VGND sg13g2_a21oi_1
X_6582_ _6582_/Y _8628_/Q _5478_/Y _6581_/X VPWR VGND sg13g2_o21ai_1
X_9370_ _9370_/Q clkload9/A _9370_/D place2507/X VPWR VGND sg13g2_dfrbpq_1
X_5533_ _8632_/D _5532_/Y _5531_/Y _5593_/B1 VPWR VGND sg13g2_a21oi_1
X_8321_ _8321_/Y _8321_/A _8349_/B VPWR VGND sg13g2_nand2_1
XFILLER_118_768 VPWR VGND sg13g2_fill_1
XFILLER_118_757 VPWR VGND sg13g2_decap_8
XFILLER_118_779 VPWR VGND sg13g2_fill_2
XFILLER_117_278 VPWR VGND sg13g2_fill_2
XFILLER_117_267 VPWR VGND sg13g2_fill_1
Xoutput2721 master_wdata_o[30] _5779_/X VPWR VGND sg13g2_buf_1
Xoutput2710 master_wdata_o[20] _5760_/Y VPWR VGND sg13g2_buf_1
X_5464_ _8690_/D _5464_/A _5468_/B_N VPWR VGND sg13g2_nor2b_1
X_8252_ _9126_/D _8252_/A1 _8053_/Y _8251_/Y VPWR VGND sg13g2_o21ai_1
Xoutput2732 slave_rdata_o[0] _4753_/Y VPWR VGND sg13g2_buf_1
X_7203_ _8884_/D _7202_/Y _8884_/Q _7213_/S VPWR VGND sg13g2_mux2_1
X_5395_ _5395_/Y _5410_/A _5395_/B VPWR VGND sg13g2_nand2_1
X_8183_ _8183_/Y _8183_/A _8191_/B VPWR VGND sg13g2_nand2_1
Xoutput2765 slave_rid_o[1] _9412_/Q VPWR VGND sg13g2_buf_1
Xoutput2754 slave_rdata_o[2] _4781_/Y VPWR VGND sg13g2_buf_1
Xoutput2743 slave_rdata_o[1] _4756_/Y VPWR VGND sg13g2_buf_1
X_4415_ _4416_/C _9227_/Q _9226_/Q _9229_/Q VPWR VGND sg13g2_nor3_1
X_4346_ _7002_/B _4346_/A _4346_/B VPWR VGND sg13g2_nor2_1
X_7134_ _7156_/A _7036_/B _6962_/Y _6974_/Y VPWR VGND sg13g2_o21ai_1
Xclkbuf_3_7__f_clk_i clkload3/A clkbuf_0_clk_i/X VPWR VGND sg13g2_buf_8
XFILLER_86_357 VPWR VGND sg13g2_decap_8
X_7065_ _7065_/Y _7162_/A _7172_/B _7080_/C VPWR VGND sg13g2_nand3_1
XFILLER_101_668 VPWR VGND sg13g2_decap_8
XFILLER_74_519 VPWR VGND sg13g2_fill_1
XFILLER_55_711 VPWR VGND sg13g2_fill_1
X_6016_ _6018_/C _8589_/A _6338_/B _6033_/D _6033_/C VPWR VGND sg13g2_nor4_1
XFILLER_100_189 VPWR VGND sg13g2_fill_1
XFILLER_100_178 VPWR VGND sg13g2_decap_8
XFILLER_67_582 VPWR VGND sg13g2_decap_8
XFILLER_27_457 VPWR VGND sg13g2_decap_4
XFILLER_36_48 VPWR VGND sg13g2_fill_1
X_7967_ _7967_/Y _7969_/A _8994_/Q _8361_/C VPWR VGND sg13g2_nand3_1
X_7898_ _8963_/D _5348_/C _7904_/A _7896_/Y VPWR VGND sg13g2_o21ai_1
X_9706_ _9706_/Q _9708_/CLK _9706_/D fanout954/X VPWR VGND sg13g2_dfrbpq_1
X_6918_ _6918_/X _9708_/Q _9629_/Q _6939_/B VPWR VGND sg13g2_and3_1
XFILLER_42_438 VPWR VGND sg13g2_decap_4
X_9637_ _9637_/Q _9649_/CLK _9637_/D fanout976/X VPWR VGND sg13g2_dfrbpq_1
X_6849_ _6849_/X _8898_/Q _8930_/Q _6905_/S VPWR VGND sg13g2_mux2_1
X_9568_ _9568_/Q _9588_/CLK _9568_/D _9568_/RESET_B VPWR VGND sg13g2_dfrbpq_1
XFILLER_109_735 VPWR VGND sg13g2_decap_8
X_9499_ _9499_/Q _9603_/CLK _9499_/D _9499_/RESET_B VPWR VGND sg13g2_dfrbpq_1
X_8519_ _8519_/Y _8563_/A _8520_/C _8520_/D VPWR VGND sg13g2_nor3_1
X_9621__2769 _9621_/RESET_B VPWR VGND sg13g2_tiehi
XFILLER_123_237 VPWR VGND sg13g2_fill_2
XFILLER_77_379 VPWR VGND sg13g2_fill_1
XFILLER_93_32 VPWR VGND sg13g2_fill_2
XFILLER_73_563 VPWR VGND sg13g2_decap_8
XFILLER_61_703 VPWR VGND sg13g2_decap_8
XFILLER_46_755 VPWR VGND sg13g2_decap_8
XFILLER_60_202 VPWR VGND sg13g2_decap_4
XFILLER_33_405 VPWR VGND sg13g2_fill_2
XFILLER_60_246 VPWR VGND sg13g2_decap_8
XFILLER_60_268 VPWR VGND sg13g2_decap_4
XFILLER_13_151 VPWR VGND sg13g2_decap_8
XFILLER_14_674 VPWR VGND sg13g2_fill_1
XFILLER_9_133 VPWR VGND sg13g2_decap_4
XFILLER_42_91 VPWR VGND sg13g2_fill_2
Xclkbuf_leaf_31_clk_i clkload8/A clkload0/A VPWR VGND sg13g2_buf_16
XFILLER_47_4 VPWR VGND sg13g2_fill_1
XFILLER_123_782 VPWR VGND sg13g2_decap_8
X_5180_ _5181_/B _5192_/C _5188_/B VPWR VGND sg13g2_nand2_1
XFILLER_68_335 VPWR VGND sg13g2_fill_1
XFILLER_96_666 VPWR VGND sg13g2_decap_8
XFILLER_84_806 VPWR VGND sg13g2_fill_2
XFILLER_49_582 VPWR VGND sg13g2_fill_1
XFILLER_37_733 VPWR VGND sg13g2_decap_4
X_8870_ _8870_/Q _9242_/CLK _8870_/D place2495/X VPWR VGND sg13g2_dfrbpq_1
XFILLER_91_371 VPWR VGND sg13g2_decap_4
X_7821_ _7822_/D _9050_/Q _7816_/B _7819_/Y VPWR VGND sg13g2_o21ai_1
X_7752_ _7753_/D _9883_/A _7771_/A2 _7794_/B1 _8889_/Q VPWR VGND sg13g2_a22oi_1
XFILLER_52_758 VPWR VGND sg13g2_fill_2
XFILLER_51_224 VPWR VGND sg13g2_fill_2
X_4964_ _4964_/Y _4961_/Y _4963_/Y _4853_/A VPWR VGND sg13g2_a21oi_1
X_6703_ _9471_/D _9512_/Q _9471_/Q _6710_/S VPWR VGND sg13g2_mux2_1
Xinput2608 _5897_/A master_rdata_i[8] VPWR VGND sg13g2_buf_1
X_7683_ _7687_/B _9074_/Q _7804_/B VPWR VGND sg13g2_nor2_1
X_9422_ _9422_/Q _9678_/CLK _9422_/D fanout978/X VPWR VGND sg13g2_dfrbpq_1
Xinput2619 _6537_/A1 slave_aid_i[1] VPWR VGND sg13g2_buf_1
XFILLER_20_622 VPWR VGND sg13g2_decap_8
X_4895_ _4895_/X _4750_/A _4785_/Y _4894_/Y VPWR VGND sg13g2_a21o_1
X_6634_ _6634_/Y _6634_/A _6651_/B VPWR VGND sg13g2_nand2_1
X_6565_ _6565_/Y _9422_/Q _6587_/B VPWR VGND sg13g2_nand2_1
X_9353_ _9353_/Q _9406_/CLK _9353_/D place2491/X VPWR VGND sg13g2_dfrbpq_1
X_9284_ _9284_/Q _9304_/CLK _9284_/D place2421/X VPWR VGND sg13g2_dfrbpq_1
X_5516_ _5516_/Y _5525_/A _5525_/B _8628_/Q _5525_/D VPWR VGND sg13g2_nand4_1
X_6496_ _6496_/Y _8892_/Q _6496_/A2 _6495_/Y _6410_/Y _6494_/Y VPWR VGND sg13g2_a221oi_1
X_8304_ _9152_/D _8350_/A1 _8039_/Y _8303_/Y VPWR VGND sg13g2_o21ai_1
XFILLER_106_727 VPWR VGND sg13g2_decap_8
X_8235_ _8235_/Y _8235_/A _8243_/B VPWR VGND sg13g2_nand2_1
X_5447_ _5448_/A _5455_/A1 _8682_/Q _8683_/Q _5451_/B2 VPWR VGND sg13g2_a22oi_1
X_5378_ _5378_/Y _7735_/A _7735_/B _7004_/C VPWR VGND sg13g2_nor3_1
XFILLER_87_622 VPWR VGND sg13g2_fill_1
X_8166_ _9083_/D _8190_/A1 _8022_/Y _8165_/Y VPWR VGND sg13g2_o21ai_1
XFILLER_101_421 VPWR VGND sg13g2_fill_1
X_4329_ _5306_/C _9884_/A VPWR VGND sg13g2_inv_1
XFILLER_86_110 VPWR VGND sg13g2_decap_8
X_8097_ _8097_/Y _8097_/A _8097_/B VPWR VGND sg13g2_nand2_1
XFILLER_59_346 VPWR VGND sg13g2_decap_4
X_7117_ _7117_/Y _7221_/A _7221_/B _7129_/C VPWR VGND sg13g2_nand3_1
X_7048_ _8836_/D _7059_/A _7046_/Y _7047_/Y VPWR VGND sg13g2_o21ai_1
XFILLER_28_733 VPWR VGND sg13g2_fill_1
XFILLER_55_585 VPWR VGND sg13g2_fill_1
XFILLER_55_563 VPWR VGND sg13g2_fill_1
X_8999_ _8999_/Q clkload4/A _8999_/D place2486/X VPWR VGND sg13g2_dfrbpq_1
XFILLER_103_97 VPWR VGND sg13g2_decap_4
XFILLER_70_544 VPWR VGND sg13g2_fill_2
XFILLER_30_419 VPWR VGND sg13g2_decap_8
XFILLER_11_666 VPWR VGND sg13g2_decap_8
XFILLER_11_644 VPWR VGND sg13g2_decap_4
XFILLER_7_626 VPWR VGND sg13g2_decap_8
XFILLER_12_72 VPWR VGND sg13g2_decap_4
XFILLER_12_61 VPWR VGND sg13g2_decap_4
XFILLER_5_0 VPWR VGND sg13g2_decap_8
XFILLER_78_600 VPWR VGND sg13g2_decap_8
XFILLER_120_774 VPWR VGND sg13g2_fill_1
XFILLER_66_806 VPWR VGND sg13g2_fill_2
XFILLER_93_658 VPWR VGND sg13g2_decap_8
XFILLER_65_349 VPWR VGND sg13g2_fill_2
XFILLER_34_725 VPWR VGND sg13g2_fill_2
XFILLER_34_758 VPWR VGND sg13g2_fill_1
XFILLER_46_596 VPWR VGND sg13g2_decap_8
XFILLER_21_419 VPWR VGND sg13g2_fill_1
XFILLER_33_257 VPWR VGND sg13g2_fill_1
X_4680_ _4681_/B _4687_/A _4480_/B _4680_/B1 VPWR VGND sg13g2_a21oi_1
Xplace2505 place2505/X place2506/X VPWR VGND sg13g2_buf_1
Xplace2538 _7221_/B _7218_/B VPWR VGND sg13g2_buf_1
X_6350_ _6350_/Y _8866_/Q _6375_/A2 _6390_/A2 _6349_/X VPWR VGND sg13g2_a22oi_1
Xplace2516 _6400_/S0 _6302_/S0 VPWR VGND sg13g2_buf_1
Xplace2527 _6421_/S1 _6400_/S1 VPWR VGND sg13g2_buf_1
X_5301_ _5301_/Y _5301_/A _5301_/B VPWR VGND sg13g2_nand2_1
Xplace1804 _5288_/B2 _5075_/X VPWR VGND sg13g2_buf_1
XFILLER_52_2 VPWR VGND sg13g2_fill_1
Xplace1815 _8409_/A _8407_/A VPWR VGND sg13g2_buf_1
Xplace1826 _8099_/B _8055_/B VPWR VGND sg13g2_buf_1
Xplace1859 _5981_/B _5960_/B VPWR VGND sg13g2_buf_1
Xplace1848 _6900_/S _6902_/S VPWR VGND sg13g2_buf_1
X_6281_ _9368_/D _6279_/X _6274_/Y _6280_/Y VPWR VGND sg13g2_a21oi_1
Xplace1837 _8007_/A _8003_/A VPWR VGND sg13g2_buf_1
Xhold3229 _8575_/C _9280_/Q VPWR VGND sg13g2_dlygate4sd3_1
X_5232_ _5359_/C _8496_/B _9486_/Q VPWR VGND sg13g2_nand2_1
Xhold3218 _8123_/A _9062_/Q VPWR VGND sg13g2_dlygate4sd3_1
Xhold3207 _8183_/A _9092_/Q VPWR VGND sg13g2_dlygate4sd3_1
X_8020_ _9020_/D _5374_/C _8019_/A _8019_/Y VPWR VGND sg13g2_o21ai_1
XFILLER_102_229 VPWR VGND sg13g2_fill_2
X_5163_ _5187_/D _5163_/A _9863_/A VPWR VGND sg13g2_nor2b_1
XFILLER_38_0 VPWR VGND sg13g2_decap_8
XFILLER_68_143 VPWR VGND sg13g2_fill_2
XFILLER_29_519 VPWR VGND sg13g2_decap_8
XFILLER_110_284 VPWR VGND sg13g2_fill_2
XFILLER_84_636 VPWR VGND sg13g2_decap_8
X_5094_ _8753_/D _5080_/A _5091_/Y _5345_/C _5288_/A1 VPWR VGND sg13g2_a22oi_1
X_8922_ _8922_/Q _9615_/CLK _8922_/D place2417/X VPWR VGND sg13g2_dfrbpq_1
XFILLER_83_146 VPWR VGND sg13g2_fill_2
XFILLER_83_179 VPWR VGND sg13g2_fill_2
XFILLER_71_319 VPWR VGND sg13g2_decap_8
XFILLER_64_360 VPWR VGND sg13g2_fill_2
X_8853_ _8853_/Q _9407_/CLK _8853_/D place2460/X VPWR VGND sg13g2_dfrbpq_1
X_7804_ _7806_/C _9204_/Q _7804_/B VPWR VGND sg13g2_nor2_1
XFILLER_37_596 VPWR VGND sg13g2_decap_8
X_5996_ _5996_/Y _8528_/C _5372_/C _5995_/Y VPWR VGND sg13g2_o21ai_1
X_8784_ _8784_/Q _9254_/CLK _8784_/D place2456/X VPWR VGND sg13g2_dfrbpq_1
XFILLER_52_566 VPWR VGND sg13g2_decap_8
X_7735_ _7735_/Y _7735_/A _7735_/B _7811_/C _7735_/D VPWR VGND sg13g2_nor4_1
XFILLER_52_599 VPWR VGND sg13g2_decap_4
X_4947_ _4947_/Y _4798_/Y _4946_/Y _4944_/Y VPWR VGND sg13g2_a21oi_1
XFILLER_32_290 VPWR VGND sg13g2_decap_4
X_4878_ _4914_/A _4880_/D _4903_/B _4880_/B VPWR VGND sg13g2_nand3_1
X_7666_ _7667_/C _7839_/C _9011_/Q _7723_/C VPWR VGND sg13g2_nor3_1
X_6617_ _6617_/Y _6617_/A _6654_/B VPWR VGND sg13g2_nand2_1
X_9405_ _9405_/Q _9406_/CLK _9405_/D place2507/A VPWR VGND sg13g2_dfrbpq_1
XFILLER_20_452 VPWR VGND sg13g2_decap_8
X_7597_ _8913_/D _7596_/Y _7812_/S _7577_/Y VPWR VGND sg13g2_a21oi_1
X_9336_ _9336_/Q _9409_/CLK _9336_/D place2393/X VPWR VGND sg13g2_dfrbpq_1
XFILLER_116_7 VPWR VGND sg13g2_decap_4
X_6548_ _6548_/X _6558_/A _9416_/Q _6737_/A _6558_/D VPWR VGND sg13g2_and4_1
X_9267_ _9267_/Q _9304_/CLK _9267_/D place2415/X VPWR VGND sg13g2_dfrbpq_1
XFILLER_3_139 VPWR VGND sg13g2_decap_8
X_6479_ _9401_/D _6484_/S _6478_/Y _6477_/Y VPWR VGND sg13g2_o21ai_1
X_8218_ _9109_/D _8222_/A1 _8092_/Y _8217_/Y VPWR VGND sg13g2_o21ai_1
X_9198_ _9198_/Q _9198_/CLK _9198_/D place2435/X VPWR VGND sg13g2_dfrbpq_1
X_8149_ _8149_/Y _8149_/A _8159_/B VPWR VGND sg13g2_nand2_1
XFILLER_75_647 VPWR VGND sg13g2_fill_2
XFILLER_47_327 VPWR VGND sg13g2_fill_1
XFILLER_75_669 VPWR VGND sg13g2_decap_8
XFILLER_74_146 VPWR VGND sg13g2_fill_2
XFILLER_74_34 VPWR VGND sg13g2_fill_2
XFILLER_90_628 VPWR VGND sg13g2_fill_2
XFILLER_90_617 VPWR VGND sg13g2_decap_8
XFILLER_55_360 VPWR VGND sg13g2_fill_2
XFILLER_43_511 VPWR VGND sg13g2_decap_8
XFILLER_16_758 VPWR VGND sg13g2_decap_8
XFILLER_90_11 VPWR VGND sg13g2_decap_8
XFILLER_31_739 VPWR VGND sg13g2_fill_1
XFILLER_7_423 VPWR VGND sg13g2_fill_2
XFILLER_99_42 VPWR VGND sg13g2_decap_4
XFILLER_99_75 VPWR VGND sg13g2_decap_8
XFILLER_3_673 VPWR VGND sg13g2_decap_8
XFILLER_3_651 VPWR VGND sg13g2_decap_4
X_9506__2874 _9506_/RESET_B VPWR VGND sg13g2_tiehi
XFILLER_78_430 VPWR VGND sg13g2_decap_4
XFILLER_39_806 VPWR VGND sg13g2_fill_2
XFILLER_38_305 VPWR VGND sg13g2_fill_2
XFILLER_65_179 VPWR VGND sg13g2_decap_4
XFILLER_0_42 VPWR VGND sg13g2_decap_8
XFILLER_46_360 VPWR VGND sg13g2_fill_2
X_5850_ _5850_/Y _5890_/A _5890_/B _5913_/A _5890_/D VPWR VGND sg13g2_nand4_1
XFILLER_61_363 VPWR VGND sg13g2_decap_4
X_5781_ _5781_/Y _5781_/A _8563_/A VPWR VGND sg13g2_nor2_1
X_4801_ _4801_/Y _4798_/Y _4800_/X _4797_/Y VPWR VGND sg13g2_a21oi_1
X_7520_ _7534_/C _9265_/Q _7520_/B VPWR VGND sg13g2_nand2_1
X_4732_ _4733_/A _9683_/Q _6569_/B _4729_/A _9207_/Q VPWR VGND sg13g2_a22oi_1
XFILLER_119_126 VPWR VGND sg13g2_decap_4
X_4663_ _9646_/D _4663_/A _4663_/B VPWR VGND sg13g2_nor2_1
X_7451_ _7453_/C _7492_/A _9000_/Q _7490_/C VPWR VGND sg13g2_nor3_1
Xclkbuf_leaf_10_jtag_tck_i_regs _9567_/CLK clkload26/A VPWR VGND sg13g2_buf_16
Xplace2313 _8517_/B _9259_/Q VPWR VGND sg13g2_buf_1
X_6402_ _6402_/Y _6415_/A1 _6470_/A2 _6402_/B1 VPWR VGND sg13g2_a21oi_1
Xplace2302 _4814_/B _4923_/A VPWR VGND sg13g2_buf_1
Xplace2346 _5735_/B _9858_/A VPWR VGND sg13g2_buf_1
Xplace2335 _5006_/A1 _4957_/D VPWR VGND sg13g2_buf_1
Xplace2324 _6247_/C _9242_/Q VPWR VGND sg13g2_buf_1
X_7382_ _7384_/B _7404_/C _7404_/B _9090_/Q VPWR VGND sg13g2_nor3_1
X_4594_ _9694_/D _4594_/A _4743_/A VPWR VGND sg13g2_nor2b_1
Xplace2357 _5319_/A _8432_/C VPWR VGND sg13g2_buf_1
Xplace2379 _8353_/C _8355_/C VPWR VGND sg13g2_buf_1
X_9121_ _9121_/Q _9183_/CLK _9121_/D place2469/X VPWR VGND sg13g2_dfrbpq_1
X_6333_ _6333_/Y _8446_/B _6333_/B _6333_/C _6333_/D VPWR VGND sg13g2_nor4_1
Xplace2368 _8056_/A _8391_/C VPWR VGND sg13g2_buf_1
XFILLER_115_376 VPWR VGND sg13g2_fill_2
Xhold3015 _9640_/D _4565_/Y VPWR VGND sg13g2_dlygate4sd3_1
X_9052_ _9052_/Q clkload5/A _9052_/D place2499/X VPWR VGND sg13g2_dfrbpq_1
X_6264_ _6265_/C _6264_/A _6264_/B _6264_/C _6332_/B VPWR VGND sg13g2_nand4_1
Xhold3004 _5653_/A _8611_/Q VPWR VGND sg13g2_dlygate4sd3_1
Xhold3048 _7014_/A _8827_/Q VPWR VGND sg13g2_dlygate4sd3_1
Xhold3026 _8149_/A _9075_/Q VPWR VGND sg13g2_dlygate4sd3_1
Xhold3037 hold3037/X _8737_/Q VPWR VGND sg13g2_dlygate4sd3_1
X_5215_ _5218_/C _5215_/A _5223_/B _5238_/A VPWR VGND sg13g2_nand3_1
X_8003_ _8003_/Y _8003_/A _9012_/Q _8401_/C VPWR VGND sg13g2_nand3_1
Xhold3059 _8569_/C _9277_/Q VPWR VGND sg13g2_dlygate4sd3_1
X_6195_ _6195_/Y _6055_/A _6379_/A2 _6195_/B1 VPWR VGND sg13g2_a21oi_1
XFILLER_96_271 VPWR VGND sg13g2_fill_1
X_5146_ _5149_/B _6519_/B _6519_/C _5146_/C _5146_/D VPWR VGND sg13g2_nor4_1
XFILLER_57_636 VPWR VGND sg13g2_fill_2
XFILLER_29_327 VPWR VGND sg13g2_decap_8
XFILLER_57_647 VPWR VGND sg13g2_fill_1
X_5077_ _8022_/D _9471_/Q _8444_/C VPWR VGND sg13g2_and2_1
X_8905_ _8905_/Q _9611_/CLK _8905_/D place2413/X VPWR VGND sg13g2_dfrbpq_1
X_9885_ _9885_/X _9885_/A VPWR VGND sg13g2_buf_1
XFILLER_25_533 VPWR VGND sg13g2_fill_1
XFILLER_80_650 VPWR VGND sg13g2_decap_8
X_8836_ _8836_/Q _9242_/CLK _8836_/D place2496/X VPWR VGND sg13g2_dfrbpq_1
X_5979_ _9328_/D _5978_/B _5977_/Y _5978_/Y VPWR VGND sg13g2_o21ai_1
X_8767_ _9873_/A _9252_/CLK _8767_/D place2391/X VPWR VGND sg13g2_dfrbpq_1
XFILLER_52_374 VPWR VGND sg13g2_decap_4
XFILLER_40_514 VPWR VGND sg13g2_fill_1
X_9556__2834 _9556_/RESET_B VPWR VGND sg13g2_tiehi
X_7718_ _7722_/B _7718_/A _7783_/B _8983_/Q VPWR VGND sg13g2_nor3_1
X_8698_ _8698_/Q _9649_/CLK _9463_/Q fanout977/X VPWR VGND sg13g2_dfrbpq_1
XFILLER_60_47 VPWR VGND sg13g2_decap_8
X_7649_ _7652_/A _9196_/Q _7724_/B VPWR VGND sg13g2_nor2_1
XFILLER_4_404 VPWR VGND sg13g2_decap_8
X_9319_ _9319_/Q _9409_/CLK _9319_/D place2396/X VPWR VGND sg13g2_dfrbpq_1
XFILLER_119_693 VPWR VGND sg13g2_decap_4
XFILLER_106_343 VPWR VGND sg13g2_decap_4
XFILLER_69_34 VPWR VGND sg13g2_fill_1
XFILLER_79_216 VPWR VGND sg13g2_decap_4
XFILLER_69_67 VPWR VGND sg13g2_decap_8
XFILLER_85_11 VPWR VGND sg13g2_decap_8
XFILLER_47_102 VPWR VGND sg13g2_fill_1
XFILLER_75_455 VPWR VGND sg13g2_fill_1
XFILLER_75_444 VPWR VGND sg13g2_fill_2
XFILLER_90_403 VPWR VGND sg13g2_decap_4
XFILLER_62_105 VPWR VGND sg13g2_fill_2
XFILLER_35_319 VPWR VGND sg13g2_decap_8
XFILLER_16_522 VPWR VGND sg13g2_fill_1
XFILLER_16_533 VPWR VGND sg13g2_decap_4
XFILLER_16_588 VPWR VGND sg13g2_decap_4
XFILLER_43_363 VPWR VGND sg13g2_fill_1
XFILLER_34_92 VPWR VGND sg13g2_fill_2
XFILLER_11_260 VPWR VGND sg13g2_decap_8
XFILLER_7_220 VPWR VGND sg13g2_decap_8
XFILLER_116_107 VPWR VGND sg13g2_fill_2
XFILLER_7_275 VPWR VGND sg13g2_decap_8
XFILLER_113_803 VPWR VGND sg13g2_fill_2
XFILLER_98_547 VPWR VGND sg13g2_fill_2
XFILLER_98_536 VPWR VGND sg13g2_decap_8
XFILLER_100_508 VPWR VGND sg13g2_fill_2
XFILLER_3_492 VPWR VGND sg13g2_fill_2
X_5000_ _5000_/Y _4813_/Y _4999_/Y _5000_/B1 VPWR VGND sg13g2_a21oi_1
XFILLER_94_720 VPWR VGND sg13g2_decap_8
XFILLER_94_753 VPWR VGND sg13g2_decap_4
XFILLER_78_293 VPWR VGND sg13g2_fill_2
XFILLER_78_282 VPWR VGND sg13g2_fill_2
XFILLER_38_124 VPWR VGND sg13g2_fill_2
XFILLER_38_179 VPWR VGND sg13g2_decap_8
XFILLER_66_499 VPWR VGND sg13g2_decap_4
X_6951_ _6951_/Y _6951_/A _6951_/B _6951_/C VPWR VGND sg13g2_nor3_1
XFILLER_54_639 VPWR VGND sg13g2_fill_1
XFILLER_53_138 VPWR VGND sg13g2_decap_8
X_5902_ _5902_/Y _5934_/A1 _9479_/Q _5901_/Y VPWR VGND sg13g2_o21ai_1
X_6882_ _9607_/D _6881_/X _9607_/Q _6902_/S VPWR VGND sg13g2_mux2_1
X_9670_ _9670_/Q _9675_/CLK _9670_/D place2443/X VPWR VGND sg13g2_dfrbpq_1
XFILLER_81_458 VPWR VGND sg13g2_fill_1
X_5833_ _5833_/Y _5891_/A1 _5906_/A2 _5833_/B1 _5891_/B2 VPWR VGND sg13g2_a22oi_1
XFILLER_22_525 VPWR VGND sg13g2_decap_8
X_8621_ _8621_/Q _9689_/CLK _8621_/D fanout949/X VPWR VGND sg13g2_dfrbpq_1
X_8552_ _8553_/A _9269_/Q _8560_/A2 _8560_/B1 _9495_/Q VPWR VGND sg13g2_a22oi_1
XFILLER_22_558 VPWR VGND sg13g2_decap_8
X_5764_ _5764_/Y _5762_/Y _5761_/Y _5763_/Y VPWR VGND sg13g2_a21oi_1
X_7503_ _7506_/C _9158_/Q _7816_/B VPWR VGND sg13g2_nor2_1
X_4715_ _9678_/D _4715_/A _6802_/S VPWR VGND sg13g2_nor2_1
X_5695_ _5696_/A _8602_/Q _5624_/X _5629_/Y _5695_/B2 VPWR VGND sg13g2_a22oi_1
X_8483_ _9246_/D _8488_/A _8483_/A2 _8482_/Y VPWR VGND sg13g2_o21ai_1
X_4646_ _4647_/B _9549_/Q _4694_/A _9550_/Q VPWR VGND sg13g2_nand3b_1
Xplace2121 _8160_/A1 _8164_/A1 VPWR VGND sg13g2_buf_1
X_7434_ _7437_/A _8842_/Q _7598_/A2 _7598_/B1 _8873_/Q VPWR VGND sg13g2_a22oi_1
Xplace2110 _7571_/B1 _8068_/D VPWR VGND sg13g2_buf_1
XFILLER_107_129 VPWR VGND sg13g2_fill_1
Xplace2143 _5763_/B1 _5050_/Y VPWR VGND sg13g2_buf_1
Xplace2132 _5291_/C _5290_/C VPWR VGND sg13g2_buf_1
Xplace2154 _7775_/C _4550_/Y VPWR VGND sg13g2_buf_1
X_4577_ _9704_/D _4590_/C _4577_/B VPWR VGND sg13g2_nor2_1
X_7365_ _7366_/D _9151_/Q _7385_/B _7407_/A VPWR VGND sg13g2_o21ai_1
Xplace2187 _7811_/B _4513_/C VPWR VGND sg13g2_buf_1
X_9104_ _9104_/Q clkload6/A _9104_/D place2435/X VPWR VGND sg13g2_dfrbpq_1
Xplace2198 _5438_/B_N _5472_/B_N VPWR VGND sg13g2_buf_1
Xplace2176 _7387_/C _7832_/C VPWR VGND sg13g2_buf_1
X_6316_ _6316_/Y _6248_/C _6315_/Y _6299_/Y VPWR VGND sg13g2_a21oi_1
Xplace2165 _5629_/A _5500_/C VPWR VGND sg13g2_buf_1
X_7296_ _7296_/Y _9054_/Q _7297_/B _7296_/C VPWR VGND sg13g2_nand3b_1
X_6247_ _6516_/C _9244_/Q _9243_/Q _6247_/C VPWR VGND sg13g2_nor3_1
X_9035_ _9035_/Q clkload8/A _9035_/D place2473/X VPWR VGND sg13g2_dfrbpq_1
X_6178_ _6178_/Y _5391_/B _6173_/A _6114_/Y _6080_/B _6176_/Y VPWR VGND sg13g2_a221oi_1
X_5129_ _5166_/B _5178_/A _5178_/B _9862_/A _5129_/D VPWR VGND sg13g2_nand4_1
XFILLER_57_455 VPWR VGND sg13g2_decap_8
XFILLER_45_606 VPWR VGND sg13g2_fill_2
XFILLER_72_425 VPWR VGND sg13g2_fill_2
XFILLER_45_639 VPWR VGND sg13g2_decap_8
X_9868_ _9868_/X _9868_/A VPWR VGND sg13g2_buf_1
XFILLER_111_64 VPWR VGND sg13g2_fill_1
XFILLER_80_480 VPWR VGND sg13g2_decap_8
Xclkbuf_leaf_5_jtag_tck_i_regs _9587_/CLK clkbuf_leaf_9_jtag_tck_i_regs/A VPWR VGND
+ sg13g2_buf_16
X_8819_ _8819_/Q _9407_/CLK _8819_/D place2426/X VPWR VGND sg13g2_dfrbpq_1
XFILLER_25_385 VPWR VGND sg13g2_fill_1
XFILLER_40_388 VPWR VGND sg13g2_decap_8
XFILLER_107_630 VPWR VGND sg13g2_decap_4
XFILLER_105_0 VPWR VGND sg13g2_decap_8
XFILLER_106_173 VPWR VGND sg13g2_fill_2
XFILLER_96_32 VPWR VGND sg13g2_decap_8
XFILLER_121_165 VPWR VGND sg13g2_decap_4
XFILLER_48_433 VPWR VGND sg13g2_fill_2
XFILLER_90_211 VPWR VGND sg13g2_fill_2
XFILLER_76_797 VPWR VGND sg13g2_fill_1
XFILLER_48_499 VPWR VGND sg13g2_decap_8
XFILLER_35_127 VPWR VGND sg13g2_decap_4
XFILLER_16_330 VPWR VGND sg13g2_decap_8
XFILLER_71_480 VPWR VGND sg13g2_decap_8
XFILLER_12_591 VPWR VGND sg13g2_fill_1
XFILLER_12_580 VPWR VGND sg13g2_decap_8
XFILLER_31_388 VPWR VGND sg13g2_fill_2
XFILLER_31_399 VPWR VGND sg13g2_decap_8
X_4500_ _4504_/A _8704_/Q _9463_/Q VPWR VGND sg13g2_and2_1
X_5480_ _6737_/B _6566_/A _6948_/B VPWR VGND sg13g2_nor2b_1
XANTENNA_1 _8664_/D VPWR VGND sg13g2_antennanp
X_4431_ _4432_/B _6090_/A _5391_/B _4430_/Y VPWR VGND sg13g2_a21oi_1
X_4362_ _4363_/B _9671_/Q _9675_/Q VPWR VGND sg13g2_nor2_1
X_7150_ _7150_/Y _7156_/A _8869_/Q VPWR VGND sg13g2_nand2_1
X_4293_ _4293_/Y _9254_/Q VPWR VGND sg13g2_inv_1
XFILLER_59_709 VPWR VGND sg13g2_decap_4
X_6101_ _6270_/C _6188_/A _6153_/D VPWR VGND sg13g2_nand2_1
X_7081_ _7081_/Y _5358_/C _7100_/A2 _7080_/Y VPWR VGND sg13g2_o21ai_1
X_6032_ _6032_/Y _6019_/A _6024_/Y _6031_/Y VPWR VGND sg13g2_a21oi_1
XFILLER_67_742 VPWR VGND sg13g2_decap_8
XFILLER_20_0 VPWR VGND sg13g2_decap_8
XFILLER_82_712 VPWR VGND sg13g2_decap_4
XFILLER_67_764 VPWR VGND sg13g2_decap_8
XFILLER_81_222 VPWR VGND sg13g2_decap_8
XFILLER_54_436 VPWR VGND sg13g2_fill_2
X_7983_ _7983_/Y _7985_/A _9002_/Q _8375_/C VPWR VGND sg13g2_nand3_1
XFILLER_26_105 VPWR VGND sg13g2_fill_2
XFILLER_82_778 VPWR VGND sg13g2_decap_8
XFILLER_82_767 VPWR VGND sg13g2_fill_2
X_6934_ _6934_/Y _9698_/Q _9631_/Q VPWR VGND sg13g2_nor2_1
X_9653_ _9653_/Q _9662_/CLK _9653_/D place2447/X VPWR VGND sg13g2_dfrbpq_1
XFILLER_35_661 VPWR VGND sg13g2_decap_8
X_6865_ _6865_/X _8906_/Q _8938_/Q _6905_/S VPWR VGND sg13g2_mux2_1
X_8604_ _8604_/Q _9708_/CLK _8604_/D fanout961/X VPWR VGND sg13g2_dfrbpq_1
X_9584_ _9584_/Q _9588_/CLK _9584_/D _9584_/RESET_B VPWR VGND sg13g2_dfrbpq_1
X_5816_ _5817_/A _9301_/Q _8585_/A2 _8585_/B1 _9498_/Q VPWR VGND sg13g2_a22oi_1
X_6796_ _9551_/D _9551_/Q _4621_/B _6798_/B VPWR VGND sg13g2_mux2_1
XFILLER_50_653 VPWR VGND sg13g2_fill_2
X_8535_ _8536_/A _9485_/Q _9484_/Q _9483_/Q VPWR VGND sg13g2_nor3_1
X_5747_ _5747_/Y _5771_/A1 _9307_/Q _5771_/B1 VPWR VGND sg13g2_a21oi_1
XFILLER_50_697 VPWR VGND sg13g2_fill_1
XFILLER_10_528 VPWR VGND sg13g2_fill_1
XFILLER_22_399 VPWR VGND sg13g2_fill_2
X_9465__2915 _9465_/RESET_B VPWR VGND sg13g2_tiehi
X_8466_ _8466_/Y _8476_/A _8466_/B _8490_/C VPWR VGND sg13g2_nand3_1
X_7417_ _7417_/Y _7402_/Y _7416_/Y _4541_/Y VPWR VGND sg13g2_o21ai_1
X_5678_ _8592_/D _5678_/A VPWR VGND sg13g2_inv_1
X_4629_ _4633_/A _4652_/A _9460_/Q _9459_/Q VPWR VGND sg13g2_nand3b_1
X_8397_ _8397_/Y _8397_/A _9199_/Q _8430_/C VPWR VGND sg13g2_nand3_1
XFILLER_116_482 VPWR VGND sg13g2_fill_2
XFILLER_104_600 VPWR VGND sg13g2_fill_1
X_7348_ _7348_/Y _7348_/A _7348_/B _7348_/C _7348_/D VPWR VGND sg13g2_nor4_1
XFILLER_9_7 VPWR VGND sg13g2_decap_8
XFILLER_1_204 VPWR VGND sg13g2_fill_1
XFILLER_2_716 VPWR VGND sg13g2_fill_1
XFILLER_103_121 VPWR VGND sg13g2_fill_2
X_7279_ _7280_/D _8960_/Q _4497_/Y _7278_/Y VPWR VGND sg13g2_o21ai_1
XFILLER_104_688 VPWR VGND sg13g2_decap_8
XFILLER_89_377 VPWR VGND sg13g2_decap_8
X_9018_ _9018_/Q clkload7/A _9018_/D place2458/X VPWR VGND sg13g2_dfrbpq_1
XFILLER_66_24 VPWR VGND sg13g2_fill_2
XFILLER_57_230 VPWR VGND sg13g2_fill_1
XFILLER_17_116 VPWR VGND sg13g2_decap_4
XFILLER_18_628 VPWR VGND sg13g2_fill_1
XFILLER_45_447 VPWR VGND sg13g2_fill_1
XFILLER_26_683 VPWR VGND sg13g2_fill_2
XFILLER_53_491 VPWR VGND sg13g2_decap_4
XFILLER_25_193 VPWR VGND sg13g2_fill_1
XFILLER_41_620 VPWR VGND sg13g2_decap_4
XFILLER_15_83 VPWR VGND sg13g2_decap_4
XFILLER_40_130 VPWR VGND sg13g2_fill_1
XFILLER_9_348 VPWR VGND sg13g2_decap_4
XFILLER_13_399 VPWR VGND sg13g2_decap_4
XFILLER_5_510 VPWR VGND sg13g2_fill_1
XFILLER_110_603 VPWR VGND sg13g2_decap_4
XFILLER_49_731 VPWR VGND sg13g2_fill_1
XFILLER_49_775 VPWR VGND sg13g2_fill_2
X_9543__2837 _9543_/RESET_B VPWR VGND sg13g2_tiehi
XFILLER_64_767 VPWR VGND sg13g2_decap_8
XFILLER_51_417 VPWR VGND sg13g2_decap_8
XFILLER_17_661 VPWR VGND sg13g2_decap_8
XFILLER_17_672 VPWR VGND sg13g2_fill_2
X_4980_ _4980_/Y _4783_/B _4977_/Y _4979_/Y VPWR VGND sg13g2_o21ai_1
XFILLER_16_182 VPWR VGND sg13g2_fill_2
XFILLER_44_480 VPWR VGND sg13g2_decap_8
X_6650_ _9446_/D _6656_/A1 _6649_/Y _6648_/Y VPWR VGND sg13g2_o21ai_1
XFILLER_82_2 VPWR VGND sg13g2_fill_1
X_5601_ _5601_/Y _8656_/Q _5498_/X _5601_/B1 _8655_/Q VPWR VGND sg13g2_a22oi_1
X_6581_ _6581_/X _6672_/A _9560_/Q _6588_/C VPWR VGND sg13g2_or3_1
X_5532_ _5532_/Y _9430_/Q _5591_/B _5589_/B1 _8632_/Q VPWR VGND sg13g2_a22oi_1
X_8320_ _9160_/D _8344_/A1 _8061_/Y _8319_/Y VPWR VGND sg13g2_o21ai_1
XFILLER_117_202 VPWR VGND sg13g2_fill_2
XFILLER_68_0 VPWR VGND sg13g2_decap_8
Xoutput2722 master_wdata_o[31] _5780_/X VPWR VGND sg13g2_buf_1
Xoutput2711 master_wdata_o[21] _5764_/Y VPWR VGND sg13g2_buf_1
Xoutput2700 master_wdata_o[11] _5728_/Y VPWR VGND sg13g2_buf_1
X_5463_ _5464_/A _5469_/A1 _8690_/Q _8691_/Q _5467_/B2 VPWR VGND sg13g2_a22oi_1
X_8251_ _8251_/Y _9126_/Q _8251_/B VPWR VGND sg13g2_nand2_1
X_7202_ _7202_/Y _5364_/C _7222_/A2 _7201_/Y VPWR VGND sg13g2_o21ai_1
X_5394_ _5410_/A _8749_/Q _5394_/B VPWR VGND sg13g2_nand2_1
Xoutput2755 slave_rdata_o[30] _5014_/Y VPWR VGND sg13g2_buf_1
Xoutput2744 slave_rdata_o[20] _4943_/Y VPWR VGND sg13g2_buf_1
X_8182_ _9091_/D _8198_/A1 _8042_/Y _8181_/Y VPWR VGND sg13g2_o21ai_1
Xoutput2766 slave_rid_o[2] _9413_/Q VPWR VGND sg13g2_buf_1
X_4414_ _4416_/B _9223_/Q _9222_/Q _9225_/Q VPWR VGND sg13g2_nor3_1
Xoutput2733 slave_rdata_o[10] _4864_/Y VPWR VGND sg13g2_buf_1
X_4345_ _4346_/B _9660_/Q _9659_/Q _9657_/Q _9209_/Q VPWR VGND sg13g2_or4_1
X_7133_ _7133_/Y _8022_/D _6977_/Y _7132_/Y _4436_/B VPWR VGND sg13g2_a22oi_1
XFILLER_101_625 VPWR VGND sg13g2_decap_8
X_7064_ _8841_/D _7063_/Y _8841_/Q _7085_/S VPWR VGND sg13g2_mux2_1
XFILLER_100_168 VPWR VGND sg13g2_decap_4
XFILLER_67_561 VPWR VGND sg13g2_fill_2
X_6015_ _6015_/Y _8816_/Q _6015_/B VPWR VGND sg13g2_nand2_1
XFILLER_94_380 VPWR VGND sg13g2_fill_2
XFILLER_94_391 VPWR VGND sg13g2_decap_8
XFILLER_70_704 VPWR VGND sg13g2_fill_1
X_9519__2861 _9519_/RESET_B VPWR VGND sg13g2_tiehi
XFILLER_27_436 VPWR VGND sg13g2_decap_8
XFILLER_82_564 VPWR VGND sg13g2_decap_8
XFILLER_54_255 VPWR VGND sg13g2_decap_8
X_7966_ _8993_/D _5347_/C _7975_/A _7965_/Y VPWR VGND sg13g2_o21ai_1
X_9705_ _9705_/Q _9708_/CLK _9705_/D fanout954/X VPWR VGND sg13g2_dfrbpq_1
XFILLER_42_417 VPWR VGND sg13g2_decap_8
X_7897_ _7897_/Y _8039_/A _8039_/B _8039_/C _7897_/D VPWR VGND sg13g2_nand4_1
XFILLER_23_642 VPWR VGND sg13g2_decap_4
X_6917_ _9623_/D _6917_/A _6917_/B VPWR VGND sg13g2_nand2_1
X_9636_ _9636_/Q _9649_/CLK _9636_/D fanout974/X VPWR VGND sg13g2_dfrbpq_1
X_6848_ _9590_/D _6847_/X _9590_/Q _6906_/S VPWR VGND sg13g2_mux2_1
XFILLER_11_804 VPWR VGND sg13g2_fill_1
X_9567_ _9567_/Q _9567_/CLK _9567_/D _9567_/RESET_B VPWR VGND sg13g2_dfrbpq_1
XFILLER_50_494 VPWR VGND sg13g2_fill_1
XFILLER_50_483 VPWR VGND sg13g2_decap_8
XFILLER_10_325 VPWR VGND sg13g2_decap_4
X_6779_ _9538_/D _9538_/Q _9448_/Q _6779_/S VPWR VGND sg13g2_mux2_1
X_8518_ _9259_/D _5361_/C _8536_/B _8517_/Y VPWR VGND sg13g2_o21ai_1
XFILLER_108_202 VPWR VGND sg13g2_fill_2
X_9498_ _9498_/Q _9603_/CLK _9498_/D _9498_/RESET_B VPWR VGND sg13g2_dfrbpq_1
X_8449_ _9229_/D _8448_/A _5375_/C _8448_/Y VPWR VGND sg13g2_o21ai_1
XFILLER_123_205 VPWR VGND sg13g2_fill_1
XFILLER_2_524 VPWR VGND sg13g2_decap_8
XFILLER_116_290 VPWR VGND sg13g2_decap_8
XFILLER_104_430 VPWR VGND sg13g2_fill_1
XFILLER_2_579 VPWR VGND sg13g2_decap_8
XFILLER_77_67 VPWR VGND sg13g2_fill_1
XFILLER_93_66 VPWR VGND sg13g2_fill_2
XFILLER_73_542 VPWR VGND sg13g2_decap_8
XFILLER_61_715 VPWR VGND sg13g2_decap_8
XFILLER_45_266 VPWR VGND sg13g2_fill_1
XFILLER_13_130 VPWR VGND sg13g2_decap_8
XFILLER_14_686 VPWR VGND sg13g2_decap_8
XFILLER_42_70 VPWR VGND sg13g2_decap_8
X_9569__2821 _9569_/RESET_B VPWR VGND sg13g2_tiehi
XFILLER_123_761 VPWR VGND sg13g2_decap_8
XFILLER_3_42 VPWR VGND sg13g2_decap_8
XFILLER_96_689 VPWR VGND sg13g2_fill_1
XFILLER_3_86 VPWR VGND sg13g2_fill_2
XFILLER_95_177 VPWR VGND sg13g2_decap_4
XFILLER_49_594 VPWR VGND sg13g2_decap_8
XFILLER_64_542 VPWR VGND sg13g2_fill_2
X_7820_ _7822_/C _7820_/A _9019_/Q _7820_/C VPWR VGND sg13g2_nor3_1
X_7751_ _7753_/C _9270_/Q _8515_/D _7808_/B1 _8809_/Q VPWR VGND sg13g2_a22oi_1
XFILLER_52_737 VPWR VGND sg13g2_decap_8
X_4963_ _4963_/Y _5017_/A1 _4962_/Y _4909_/Y VPWR VGND sg13g2_o21ai_1
X_7682_ _7696_/A _9296_/Q _7843_/A2 _7843_/B1 _9328_/Q _7681_/Y VPWR VGND sg13g2_a221oi_1
XFILLER_51_258 VPWR VGND sg13g2_decap_8
X_6702_ _9470_/D _9511_/Q _9470_/Q _6702_/S VPWR VGND sg13g2_mux2_1
X_6633_ _9441_/D _6653_/A1 _6632_/Y _6631_/Y VPWR VGND sg13g2_o21ai_1
Xinput2609 _5905_/A master_rdata_i[9] VPWR VGND sg13g2_buf_1
XFILLER_20_601 VPWR VGND sg13g2_decap_8
X_4894_ _4894_/Y _4824_/Y _4959_/B _5017_/A1 VPWR VGND sg13g2_a21oi_1
X_9421_ _9421_/Q _9511_/CLK _9421_/D fanout958/X VPWR VGND sg13g2_dfrbpq_1
XFILLER_118_522 VPWR VGND sg13g2_decap_4
X_6564_ _6587_/B _6569_/C _6569_/A _6569_/D VPWR VGND sg13g2_nand3_1
X_9352_ _9352_/Q clkload9/A _9352_/D place2503/X VPWR VGND sg13g2_dfrbpq_1
XFILLER_20_689 VPWR VGND sg13g2_decap_8
X_9283_ _9283_/Q _9305_/CLK _9283_/D place2395/X VPWR VGND sg13g2_dfrbpq_1
X_5515_ _8626_/D _5514_/Y _5513_/Y _5602_/B1 VPWR VGND sg13g2_a21oi_1
X_8303_ _8303_/Y _8303_/A _8349_/B VPWR VGND sg13g2_nand2_1
X_6495_ _6495_/Y _4425_/Y _6306_/Y _6399_/D VPWR VGND sg13g2_o21ai_1
X_8234_ _9117_/D _8244_/A1 _8029_/Y _8233_/Y VPWR VGND sg13g2_o21ai_1
X_5446_ _8681_/D _5446_/A _5454_/B_N VPWR VGND sg13g2_nor2b_1
XFILLER_105_227 VPWR VGND sg13g2_decap_4
XFILLER_99_472 VPWR VGND sg13g2_decap_8
X_5377_ _5377_/X _7811_/A _7811_/B _8743_/D _6982_/A VPWR VGND sg13g2_or4_1
XFILLER_87_601 VPWR VGND sg13g2_decap_8
X_8165_ _8165_/Y _8165_/A _8191_/B VPWR VGND sg13g2_nand2_1
XFILLER_101_433 VPWR VGND sg13g2_fill_1
X_4328_ _5306_/B _9883_/A VPWR VGND sg13g2_inv_1
X_8096_ _9048_/D _8098_/A1 _8095_/Y _8094_/Y VPWR VGND sg13g2_o21ai_1
X_7116_ _8858_/D _7115_/Y _8858_/Q _7131_/S VPWR VGND sg13g2_mux2_1
XFILLER_87_656 VPWR VGND sg13g2_fill_2
X_7047_ _7047_/Y _7059_/A _8836_/Q VPWR VGND sg13g2_nand2_1
XFILLER_86_199 VPWR VGND sg13g2_fill_1
XFILLER_86_177 VPWR VGND sg13g2_fill_1
XFILLER_86_166 VPWR VGND sg13g2_decap_8
XFILLER_103_76 VPWR VGND sg13g2_decap_8
XFILLER_70_512 VPWR VGND sg13g2_decap_8
X_8998_ _8998_/Q clkload8/A _8998_/D place2467/X VPWR VGND sg13g2_dfrbpq_1
XFILLER_42_203 VPWR VGND sg13g2_fill_1
XFILLER_70_523 VPWR VGND sg13g2_decap_8
X_7949_ _8986_/D _5371_/C _7950_/A _7948_/Y VPWR VGND sg13g2_o21ai_1
XFILLER_63_25 VPWR VGND sg13g2_decap_4
XFILLER_42_236 VPWR VGND sg13g2_fill_2
XFILLER_70_578 VPWR VGND sg13g2_decap_4
XFILLER_70_589 VPWR VGND sg13g2_decap_8
XFILLER_11_601 VPWR VGND sg13g2_decap_8
XFILLER_10_100 VPWR VGND sg13g2_fill_1
X_9619_ _9619_/Q _9620_/CLK _9619_/D _9619_/RESET_B VPWR VGND sg13g2_dfrbpq_1
XFILLER_10_133 VPWR VGND sg13g2_decap_4
XFILLER_6_126 VPWR VGND sg13g2_fill_1
XFILLER_88_55 VPWR VGND sg13g2_decap_8
XFILLER_104_260 VPWR VGND sg13g2_fill_2
XFILLER_2_398 VPWR VGND sg13g2_fill_1
XFILLER_78_656 VPWR VGND sg13g2_fill_2
XFILLER_18_200 VPWR VGND sg13g2_decap_4
XFILLER_92_125 VPWR VGND sg13g2_fill_2
XFILLER_58_391 VPWR VGND sg13g2_fill_2
XFILLER_19_745 VPWR VGND sg13g2_fill_1
XFILLER_19_767 VPWR VGND sg13g2_decap_8
XFILLER_61_501 VPWR VGND sg13g2_fill_1
XFILLER_18_299 VPWR VGND sg13g2_decap_8
XFILLER_61_578 VPWR VGND sg13g2_decap_8
XFILLER_61_589 VPWR VGND sg13g2_fill_1
X_9493__2887 _9493_/RESET_B VPWR VGND sg13g2_tiehi
Xplace2528 _6400_/S1 _6480_/S1 VPWR VGND sg13g2_buf_1
Xplace2506 place2506/X place2507/X VPWR VGND sg13g2_buf_1
Xplace2517 _6440_/S0 _6421_/S0 VPWR VGND sg13g2_buf_1
X_5300_ _5301_/B _5316_/A _5313_/C _9882_/A _9883_/A VPWR VGND sg13g2_nand4_1
Xplace1816 _8221_/B _8219_/B VPWR VGND sg13g2_buf_1
Xplace1805 _8428_/A _8430_/A VPWR VGND sg13g2_buf_1
Xplace2539 _7236_/D _7218_/B VPWR VGND sg13g2_buf_1
XFILLER_6_660 VPWR VGND sg13g2_decap_8
Xplace1827 _8052_/B _8055_/B VPWR VGND sg13g2_buf_1
XFILLER_115_536 VPWR VGND sg13g2_decap_8
Xplace1849 _6910_/S _6902_/S VPWR VGND sg13g2_buf_1
Xplace1838 _7948_/A _7934_/A VPWR VGND sg13g2_buf_1
XFILLER_5_181 VPWR VGND sg13g2_fill_2
X_6280_ _6280_/Y _6328_/C _6328_/A _6280_/B1 VPWR VGND sg13g2_a21oi_1
X_5231_ _8766_/D _5274_/A1 _5358_/C _5230_/Y _5274_/B2 VPWR VGND sg13g2_a22oi_1
Xhold3208 _8269_/A _9135_/Q VPWR VGND sg13g2_dlygate4sd3_1
Xhold3219 _4467_/A _9679_/Q VPWR VGND sg13g2_dlygate4sd3_1
X_5162_ _5163_/A _8517_/B _9862_/A VPWR VGND sg13g2_nor2_1
X_5093_ _5345_/C _8061_/A _9472_/Q VPWR VGND sg13g2_nand2_1
XFILLER_68_155 VPWR VGND sg13g2_decap_8
X_8921_ _8921_/Q _9615_/CLK _8921_/D place2418/X VPWR VGND sg13g2_dfrbpq_1
XFILLER_96_486 VPWR VGND sg13g2_decap_8
XFILLER_68_177 VPWR VGND sg13g2_decap_8
XFILLER_56_328 VPWR VGND sg13g2_fill_1
XFILLER_68_199 VPWR VGND sg13g2_decap_8
XFILLER_49_391 VPWR VGND sg13g2_decap_8
XFILLER_83_158 VPWR VGND sg13g2_fill_2
X_8852_ _8852_/Q _9252_/CLK _8852_/D place2426/X VPWR VGND sg13g2_dfrbpq_1
XFILLER_25_715 VPWR VGND sg13g2_decap_8
XFILLER_37_553 VPWR VGND sg13g2_decap_8
X_8783_ _9889_/A _9260_/CLK _8783_/D place2394/X VPWR VGND sg13g2_dfrbpq_1
X_7803_ _7806_/B _7803_/A _7803_/B _9111_/Q VPWR VGND sg13g2_nor3_1
XFILLER_52_512 VPWR VGND sg13g2_decap_8
X_5995_ _5995_/Y _5995_/A _6004_/B _6004_/C VPWR VGND sg13g2_nand3_1
X_7734_ _7735_/D _9298_/Q _7828_/A2 _7788_/B1 _8857_/Q _7733_/Y VPWR VGND sg13g2_a221oi_1
XFILLER_33_770 VPWR VGND sg13g2_decap_8
X_4946_ _4946_/Y _5012_/A _5012_/D _4946_/C VPWR VGND sg13g2_nand3_1
X_4877_ _4877_/Y _4872_/Y _4876_/Y _4853_/A VPWR VGND sg13g2_a21oi_1
XFILLER_32_280 VPWR VGND sg13g2_decap_4
X_7665_ _7667_/D _9042_/Q _7725_/B _7664_/X VPWR VGND sg13g2_o21ai_1
X_6616_ _9436_/D _6656_/A1 _6615_/Y _6614_/Y VPWR VGND sg13g2_o21ai_1
X_7596_ _7596_/Y _7581_/Y _7595_/Y _4541_/Y VPWR VGND sg13g2_o21ai_1
X_9404_ _9404_/Q _9406_/CLK _9404_/D place2390/X VPWR VGND sg13g2_dfrbpq_1
X_9335_ _9335_/Q _9409_/CLK _9335_/D place2393/X VPWR VGND sg13g2_dfrbpq_1
XFILLER_20_486 VPWR VGND sg13g2_fill_2
X_6547_ _9415_/D _8656_/Q _6544_/Y _6543_/X VPWR VGND sg13g2_a21o_1
XFILLER_118_363 VPWR VGND sg13g2_fill_1
Xclkbuf_2_3__f_jtag_tck_i_regs clkload26/A clkbuf_0_jtag_tck_i_regs/X VPWR VGND sg13g2_buf_8
XFILLER_4_608 VPWR VGND sg13g2_fill_2
X_9266_ _9266_/Q _9615_/CLK _9266_/D place2419/X VPWR VGND sg13g2_dfrbpq_1
XFILLER_106_536 VPWR VGND sg13g2_decap_8
X_6478_ _6478_/Y _8889_/Q _6511_/A2 _6476_/Y _6410_/Y _6474_/Y VPWR VGND sg13g2_a221oi_1
X_8217_ _8217_/Y _8217_/A _8221_/B VPWR VGND sg13g2_nand2_1
X_5429_ _5430_/A _5429_/A1 _5439_/A1 _5428_/Y VPWR VGND sg13g2_a21oi_1
X_9197_ _9197_/Q clkload8/A _9197_/D place2467/X VPWR VGND sg13g2_dfrbpq_1
X_8148_ _9074_/D _8156_/A1 _8080_/Y _8147_/Y VPWR VGND sg13g2_o21ai_1
XFILLER_58_25 VPWR VGND sg13g2_fill_2
XFILLER_75_626 VPWR VGND sg13g2_decap_8
X_8079_ _8079_/Y _8079_/A _8101_/B VPWR VGND sg13g2_nand2_1
XFILLER_59_166 VPWR VGND sg13g2_fill_2
XFILLER_74_125 VPWR VGND sg13g2_decap_8
XFILLER_28_542 VPWR VGND sg13g2_fill_2
XFILLER_74_158 VPWR VGND sg13g2_decap_8
Xclkbuf_leaf_30_clk_i clkload7/A clkload0/A VPWR VGND sg13g2_buf_16
XFILLER_28_564 VPWR VGND sg13g2_fill_1
XFILLER_83_681 VPWR VGND sg13g2_fill_1
XFILLER_70_320 VPWR VGND sg13g2_decap_4
XFILLER_28_586 VPWR VGND sg13g2_fill_2
XFILLER_15_236 VPWR VGND sg13g2_decap_4
XFILLER_43_545 VPWR VGND sg13g2_decap_8
XFILLER_70_364 VPWR VGND sg13g2_fill_1
XFILLER_90_56 VPWR VGND sg13g2_fill_2
XFILLER_7_402 VPWR VGND sg13g2_decap_8
XFILLER_109_341 VPWR VGND sg13g2_decap_4
XFILLER_99_32 VPWR VGND sg13g2_fill_1
XFILLER_109_396 VPWR VGND sg13g2_fill_1
XFILLER_112_517 VPWR VGND sg13g2_decap_4
XFILLER_98_729 VPWR VGND sg13g2_decap_8
X_9478__2902 _9478_/RESET_B VPWR VGND sg13g2_tiehi
XFILLER_2_151 VPWR VGND sg13g2_decap_8
XFILLER_120_550 VPWR VGND sg13g2_decap_8
XFILLER_2_184 VPWR VGND sg13g2_fill_2
XFILLER_120_561 VPWR VGND sg13g2_decap_4
XFILLER_93_401 VPWR VGND sg13g2_fill_1
XFILLER_48_80 VPWR VGND sg13g2_decap_8
XFILLER_80_106 VPWR VGND sg13g2_fill_1
XFILLER_0_21 VPWR VGND sg13g2_decap_8
XFILLER_19_575 VPWR VGND sg13g2_decap_8
XFILLER_61_342 VPWR VGND sg13g2_fill_2
X_4800_ _4800_/X _4816_/A _9340_/Q _4800_/C VPWR VGND sg13g2_or3_1
X_5780_ _5780_/X _9321_/Q _9337_/Q _9313_/Q _9329_/Q _5938_/A _5843_/A2 VPWR VGND
+ sg13g2_mux4_1
XFILLER_15_770 VPWR VGND sg13g2_fill_1
X_4731_ _9684_/D _6956_/S _4729_/B _4730_/Y VPWR VGND sg13g2_o21ai_1
X_4662_ _4663_/B _9644_/Q _4666_/A _9646_/Q VPWR VGND sg13g2_a21oi_1
X_7450_ _7450_/X _7492_/A _7492_/B _8969_/Q VPWR VGND sg13g2_or3_1
XFILLER_30_762 VPWR VGND sg13g2_decap_8
Xplace2303 _4923_/A _4776_/B VPWR VGND sg13g2_buf_1
X_6401_ _6401_/Y _8876_/Q _6411_/A2 _6400_/X _6401_/B2 _6399_/Y VPWR VGND sg13g2_a221oi_1
Xplace2314 _5096_/C _9259_/Q VPWR VGND sg13g2_buf_1
Xplace2347 _8430_/C _8414_/C VPWR VGND sg13g2_buf_1
X_7381_ _7384_/A _9183_/Q _7381_/B VPWR VGND sg13g2_nor2_1
X_9120_ _9120_/Q _9183_/CLK _9120_/D place2471/X VPWR VGND sg13g2_dfrbpq_1
X_4593_ _4593_/Y _9703_/Q _4593_/B VPWR VGND sg13g2_nor2_1
Xplace2336 _4957_/D _4880_/B VPWR VGND sg13g2_buf_1
Xplace2325 _8446_/B _9228_/Q VPWR VGND sg13g2_buf_1
XFILLER_115_333 VPWR VGND sg13g2_decap_4
Xplace2358 _8432_/C _8426_/C VPWR VGND sg13g2_buf_1
XFILLER_50_0 VPWR VGND sg13g2_fill_2
Xplace2369 _8391_/C _8407_/C VPWR VGND sg13g2_buf_1
X_6332_ _6333_/D _9241_/Q _6332_/B _6332_/C _6516_/C VPWR VGND sg13g2_nand4_1
X_6263_ _6264_/C _6509_/C _6160_/D _6451_/A VPWR VGND sg13g2_a21o_1
Xhold3005 _5659_/A2 _5658_/Y VPWR VGND sg13g2_dlygate4sd3_1
X_9051_ _9051_/Q _9501_/CLK _9051_/D place2468/X VPWR VGND sg13g2_dfrbpq_1
XFILLER_88_228 VPWR VGND sg13g2_decap_4
XFILLER_69_420 VPWR VGND sg13g2_fill_2
Xhold3038 _9676_/D _4470_/Y VPWR VGND sg13g2_dlygate4sd3_1
Xhold3027 _6213_/B1 _9361_/Q VPWR VGND sg13g2_dlygate4sd3_1
X_5214_ _5356_/C _6959_/B _9483_/Q VPWR VGND sg13g2_nand2_1
Xhold3016 _8119_/A _9060_/Q VPWR VGND sg13g2_dlygate4sd3_1
X_8002_ _9011_/D _5365_/C _8007_/A _8001_/Y VPWR VGND sg13g2_o21ai_1
Xhold3049 _6600_/A _9432_/Q VPWR VGND sg13g2_dlygate4sd3_1
X_6194_ _6194_/X _8972_/Q _9034_/Q _9096_/Q _9158_/Q _6421_/S0 _6400_/S1 VPWR VGND
+ sg13g2_mux4_1
XFILLER_97_784 VPWR VGND sg13g2_fill_1
X_5145_ _5152_/A _5191_/A _5139_/B _5166_/B VPWR VGND sg13g2_o21ai_1
XFILLER_29_317 VPWR VGND sg13g2_decap_4
X_5076_ _5235_/A _7775_/C _7775_/A _7028_/C _5373_/B VPWR VGND sg13g2_nor4_1
XFILLER_56_114 VPWR VGND sg13g2_decap_8
X_8904_ _8904_/Q _9603_/CLK _8904_/D place2413/X VPWR VGND sg13g2_dfrbpq_1
XFILLER_25_501 VPWR VGND sg13g2_decap_8
X_9884_ _9884_/X _9884_/A VPWR VGND sg13g2_buf_1
X_8835_ _8835_/Q _9242_/CLK _8835_/D place2495/X VPWR VGND sg13g2_dfrbpq_1
X_5978_ _5978_/Y _9328_/Q _5978_/B VPWR VGND sg13g2_nand2_1
X_8766_ _9872_/A _9260_/CLK _8766_/D place2400/X VPWR VGND sg13g2_dfrbpq_1
XFILLER_25_578 VPWR VGND sg13g2_fill_2
X_7717_ _8919_/D _8919_/Q _7716_/Y _7774_/S VPWR VGND sg13g2_mux2_1
X_8697_ _8697_/Q _9701_/CLK _8697_/D fanout960/X VPWR VGND sg13g2_dfrbpq_1
XFILLER_40_537 VPWR VGND sg13g2_decap_4
X_4929_ _4929_/Y _4999_/B _4816_/C _4914_/B _4998_/B _4914_/A VPWR VGND sg13g2_a221oi_1
X_7648_ _7652_/D _9165_/Q _7544_/B _7785_/A VPWR VGND sg13g2_o21ai_1
XFILLER_119_683 VPWR VGND sg13g2_decap_4
X_7579_ _7581_/B _8850_/Q _7579_/A2 _7269_/X _8819_/Q VPWR VGND sg13g2_a22oi_1
X_9318_ _9318_/Q _9410_/CLK _9318_/D place2396/X VPWR VGND sg13g2_dfrbpq_1
X_9597__2793 _9597_/RESET_B VPWR VGND sg13g2_tiehi
XFILLER_79_206 VPWR VGND sg13g2_decap_4
X_9249_ _9249_/Q _9251_/CLK _9249_/D place2478/X VPWR VGND sg13g2_dfrbpq_1
XFILLER_0_655 VPWR VGND sg13g2_decap_8
XFILLER_102_583 VPWR VGND sg13g2_decap_8
XFILLER_85_89 VPWR VGND sg13g2_decap_4
XFILLER_56_681 VPWR VGND sg13g2_fill_2
XFILLER_16_567 VPWR VGND sg13g2_decap_8
XFILLER_43_386 VPWR VGND sg13g2_decap_8
XFILLER_34_60 VPWR VGND sg13g2_decap_8
XFILLER_12_751 VPWR VGND sg13g2_decap_4
XFILLER_8_799 VPWR VGND sg13g2_fill_2
XFILLER_109_160 VPWR VGND sg13g2_fill_2
XFILLER_7_298 VPWR VGND sg13g2_fill_1
XFILLER_112_325 VPWR VGND sg13g2_fill_2
XFILLER_3_471 VPWR VGND sg13g2_decap_8
XFILLER_39_604 VPWR VGND sg13g2_decap_4
XFILLER_120_391 VPWR VGND sg13g2_decap_8
XFILLER_93_220 VPWR VGND sg13g2_fill_1
XFILLER_66_445 VPWR VGND sg13g2_fill_2
XFILLER_38_114 VPWR VGND sg13g2_fill_1
X_6950_ _9634_/D _9634_/Q _6945_/B _6952_/S VPWR VGND sg13g2_mux2_1
XFILLER_38_147 VPWR VGND sg13g2_decap_4
X_5901_ _5901_/Y _5901_/A _5901_/B _5925_/C VPWR VGND sg13g2_nand3_1
XFILLER_66_489 VPWR VGND sg13g2_decap_4
XFILLER_47_692 VPWR VGND sg13g2_decap_8
X_6881_ _6881_/X _8914_/Q _8946_/Q _6909_/S VPWR VGND sg13g2_mux2_1
X_5832_ _5832_/Y _5890_/A _5890_/B _5897_/A _5890_/D VPWR VGND sg13g2_nand4_1
XFILLER_22_504 VPWR VGND sg13g2_decap_8
X_8620_ _8620_/Q _9689_/CLK _8620_/D fanout949/X VPWR VGND sg13g2_dfrbpq_1
X_8551_ _9268_/D _8551_/A VPWR VGND sg13g2_inv_1
X_5763_ _5763_/Y _5739_/A _9311_/Q _5763_/B1 VPWR VGND sg13g2_a21oi_1
XFILLER_98_0 VPWR VGND sg13g2_decap_8
XFILLER_61_194 VPWR VGND sg13g2_decap_8
X_4714_ _6802_/S _4715_/A _4714_/B _4714_/C VPWR VGND sg13g2_nor3_1
X_7502_ _7506_/B _9189_/Q _7815_/B _7822_/A VPWR VGND sg13g2_o21ai_1
X_5694_ _8600_/D _5694_/A VPWR VGND sg13g2_inv_1
XFILLER_30_592 VPWR VGND sg13g2_decap_4
X_8482_ _8482_/Y _8488_/A _9246_/Q _8492_/C VPWR VGND sg13g2_nand3_1
X_4645_ _4647_/A _4694_/A _9552_/Q _9551_/Q VPWR VGND sg13g2_nand3b_1
X_7433_ _7433_/Y _7433_/A _7433_/B _7433_/C VPWR VGND sg13g2_nand3_1
Xplace2100 _7411_/B _7838_/B VPWR VGND sg13g2_buf_1
Xplace2111 _7512_/B1 _8056_/D VPWR VGND sg13g2_buf_1
Xplace2144 _5939_/A _5938_/A VPWR VGND sg13g2_buf_1
Xplace2133 _8487_/A2 _5363_/C VPWR VGND sg13g2_buf_1
X_4576_ _4577_/B _4576_/A _4580_/B VPWR VGND sg13g2_nor2_1
X_7364_ _7366_/C _9182_/Q _7381_/B VPWR VGND sg13g2_nor2_1
Xplace2122 _8164_/A1 _7017_/Y VPWR VGND sg13g2_buf_1
Xplace2155 _8039_/B _7032_/C VPWR VGND sg13g2_buf_1
XFILLER_104_804 VPWR VGND sg13g2_fill_1
Xplace2166 _5585_/D _5597_/D VPWR VGND sg13g2_buf_1
Xplace2188 _7132_/B _7029_/A VPWR VGND sg13g2_buf_1
X_9103_ _9103_/Q _9254_/CLK _9103_/D place2453/X VPWR VGND sg13g2_dfrbpq_1
XFILLER_1_408 VPWR VGND sg13g2_fill_1
X_6315_ _6315_/Y _9239_/Q _6144_/D _6509_/B VPWR VGND sg13g2_o21ai_1
Xplace2177 _7832_/C _5343_/B VPWR VGND sg13g2_buf_1
XFILLER_115_163 VPWR VGND sg13g2_fill_2
X_7295_ _7299_/B _7425_/C _8992_/Q _7295_/C VPWR VGND sg13g2_nor3_1
Xplace2199 _5454_/B_N _5468_/B_N VPWR VGND sg13g2_buf_1
X_9034_ _9034_/Q clkload8/A _9034_/D place2475/X VPWR VGND sg13g2_dfrbpq_1
X_6246_ _6249_/B _6451_/B _9245_/Q _6451_/D _6246_/D VPWR VGND sg13g2_nor4_1
XFILLER_57_401 VPWR VGND sg13g2_decap_8
X_6177_ _6177_/Y _5391_/B _6173_/A _6176_/Y VPWR VGND sg13g2_a21oi_1
X_5128_ _5166_/A _9862_/A _5130_/B VPWR VGND sg13g2_nand2b_1
XFILLER_57_445 VPWR VGND sg13g2_fill_2
XFILLER_85_765 VPWR VGND sg13g2_decap_8
XFILLER_29_158 VPWR VGND sg13g2_decap_8
X_5059_ _8528_/B _5035_/Y _9410_/Q _5126_/B VPWR VGND sg13g2_a21oi_1
XFILLER_72_459 VPWR VGND sg13g2_decap_4
X_9867_ _9867_/X _9867_/A VPWR VGND sg13g2_buf_1
XFILLER_53_640 VPWR VGND sg13g2_fill_2
XFILLER_53_662 VPWR VGND sg13g2_fill_2
X_8818_ _8818_/Q _9414_/CLK _8818_/D place2503/X VPWR VGND sg13g2_dfrbpq_1
XFILLER_41_802 VPWR VGND sg13g2_fill_2
XFILLER_25_397 VPWR VGND sg13g2_decap_8
X_8749_ _8749_/Q _9254_/CLK _8749_/D place2456/X VPWR VGND sg13g2_dfrbpq_1
XFILLER_40_367 VPWR VGND sg13g2_decap_8
XFILLER_5_725 VPWR VGND sg13g2_decap_4
XFILLER_20_40 VPWR VGND sg13g2_fill_1
XFILLER_122_612 VPWR VGND sg13g2_decap_4
XFILLER_95_529 VPWR VGND sg13g2_decap_8
XFILLER_0_452 VPWR VGND sg13g2_decap_4
XFILLER_121_188 VPWR VGND sg13g2_decap_8
XFILLER_88_592 VPWR VGND sg13g2_fill_2
XFILLER_0_485 VPWR VGND sg13g2_fill_2
XFILLER_91_713 VPWR VGND sg13g2_fill_1
XFILLER_75_297 VPWR VGND sg13g2_decap_4
XFILLER_36_629 VPWR VGND sg13g2_decap_8
XFILLER_90_234 VPWR VGND sg13g2_fill_1
XFILLER_16_342 VPWR VGND sg13g2_fill_1
XFILLER_31_301 VPWR VGND sg13g2_fill_2
XFILLER_16_397 VPWR VGND sg13g2_fill_1
XFILLER_43_172 VPWR VGND sg13g2_fill_2
XFILLER_31_378 VPWR VGND sg13g2_decap_4
XFILLER_117_428 VPWR VGND sg13g2_decap_4
XFILLER_6_42 VPWR VGND sg13g2_decap_8
X_4430_ _4430_/Y _6071_/C _9343_/Q _8749_/Q VPWR VGND sg13g2_nand3_1
XANTENNA_2 _5423_/B VPWR VGND sg13g2_antennanp
X_6100_ _6509_/B _6188_/A _6153_/D VPWR VGND sg13g2_and2_1
X_4361_ _8735_/D _9681_/D VPWR VGND sg13g2_inv_1
XFILLER_113_634 VPWR VGND sg13g2_fill_2
XFILLER_112_122 VPWR VGND sg13g2_fill_2
X_4292_ _5085_/D _9260_/Q VPWR VGND sg13g2_inv_1
X_7080_ _7080_/Y _7179_/A _7182_/D _7080_/C VPWR VGND sg13g2_nand3_1
XFILLER_112_155 VPWR VGND sg13g2_fill_1
XFILLER_58_209 VPWR VGND sg13g2_fill_1
X_6031_ _6031_/Y _6046_/D _6041_/B _6031_/C VPWR VGND sg13g2_nand3_1
XFILLER_39_401 VPWR VGND sg13g2_decap_4
XFILLER_66_220 VPWR VGND sg13g2_decap_4
XFILLER_39_434 VPWR VGND sg13g2_decap_8
XFILLER_94_562 VPWR VGND sg13g2_decap_4
XFILLER_94_540 VPWR VGND sg13g2_fill_2
XFILLER_27_618 VPWR VGND sg13g2_fill_1
XFILLER_39_445 VPWR VGND sg13g2_decap_8
XFILLER_66_264 VPWR VGND sg13g2_decap_4
XFILLER_27_629 VPWR VGND sg13g2_decap_8
X_7982_ _9001_/D _5355_/C _7985_/A _7981_/Y VPWR VGND sg13g2_o21ai_1
X_6933_ _9629_/D _9630_/Q _6931_/Y _6932_/X VPWR VGND sg13g2_a21o_1
XFILLER_35_640 VPWR VGND sg13g2_decap_8
X_9652_ _9652_/Q _9662_/CLK _9652_/D place2446/X VPWR VGND sg13g2_dfrbpq_1
X_6864_ _9598_/D _6863_/X _9598_/Q _6900_/S VPWR VGND sg13g2_mux2_1
XFILLER_62_470 VPWR VGND sg13g2_fill_1
X_5815_ _9300_/D _5815_/A VPWR VGND sg13g2_inv_1
X_8603_ _8603_/Q _9689_/CLK _8603_/D fanout949/X VPWR VGND sg13g2_dfrbpq_1
X_9583_ _9583_/Q _9588_/CLK _9583_/D _9583_/RESET_B VPWR VGND sg13g2_dfrbpq_1
X_6795_ _9550_/D _9550_/Q _9552_/Q _6795_/S VPWR VGND sg13g2_mux2_1
XFILLER_22_356 VPWR VGND sg13g2_decap_8
XFILLER_22_367 VPWR VGND sg13g2_decap_8
X_8534_ _8534_/Y _8534_/A _9263_/Q _8534_/C VPWR VGND sg13g2_nand3_1
X_5746_ _5746_/Y _9315_/Q _5765_/B _5745_/Y VPWR VGND sg13g2_o21ai_1
X_5677_ _5678_/A _8593_/Q _5677_/A2 _5677_/B1 _5677_/B2 VPWR VGND sg13g2_a22oi_1
X_8465_ _9237_/D _8476_/A _5351_/C _8464_/Y VPWR VGND sg13g2_o21ai_1
X_4628_ _4650_/B _9459_/Q _9460_/Q VPWR VGND sg13g2_nand2_1
X_7416_ _7416_/Y _7416_/A _7416_/B _7416_/C VPWR VGND sg13g2_nand3_1
X_8396_ _9198_/D _5275_/Y _8401_/A _8395_/Y VPWR VGND sg13g2_o21ai_1
X_4559_ _4560_/D _5826_/A _9211_/Q _4558_/Y VPWR VGND sg13g2_o21ai_1
X_7347_ _7348_/D _9150_/Q _7411_/B VPWR VGND sg13g2_nor2_1
X_7278_ _7278_/Y _9053_/Q _7297_/B _7278_/C VPWR VGND sg13g2_nand3b_1
XFILLER_106_43 VPWR VGND sg13g2_fill_1
XFILLER_77_518 VPWR VGND sg13g2_decap_8
X_6229_ _6229_/Y _6229_/A _6229_/B VPWR VGND sg13g2_nand2_1
X_9017_ _9017_/Q clkload7/A _9017_/D place2458/X VPWR VGND sg13g2_dfrbpq_1
XFILLER_103_188 VPWR VGND sg13g2_fill_1
XFILLER_57_242 VPWR VGND sg13g2_decap_8
XFILLER_18_607 VPWR VGND sg13g2_decap_8
XFILLER_85_595 VPWR VGND sg13g2_decap_8
XFILLER_85_584 VPWR VGND sg13g2_decap_8
XFILLER_122_42 VPWR VGND sg13g2_decap_8
XFILLER_45_437 VPWR VGND sg13g2_decap_4
XFILLER_60_429 VPWR VGND sg13g2_fill_1
XFILLER_13_323 VPWR VGND sg13g2_decap_4
XFILLER_25_172 VPWR VGND sg13g2_decap_8
XFILLER_15_51 VPWR VGND sg13g2_decap_4
XFILLER_13_378 VPWR VGND sg13g2_decap_8
XFILLER_5_599 VPWR VGND sg13g2_decap_8
XFILLER_68_518 VPWR VGND sg13g2_fill_2
XFILLER_95_337 VPWR VGND sg13g2_decap_4
XFILLER_48_231 VPWR VGND sg13g2_decap_8
XFILLER_63_212 VPWR VGND sg13g2_decap_8
XFILLER_36_415 VPWR VGND sg13g2_decap_8
XFILLER_36_426 VPWR VGND sg13g2_fill_1
XFILLER_91_554 VPWR VGND sg13g2_decap_8
XFILLER_63_223 VPWR VGND sg13g2_fill_2
XFILLER_56_91 VPWR VGND sg13g2_decap_8
XFILLER_36_459 VPWR VGND sg13g2_fill_2
XFILLER_63_267 VPWR VGND sg13g2_decap_8
XFILLER_23_109 VPWR VGND sg13g2_decap_8
X_5600_ _5600_/Y _9453_/Q _5600_/B VPWR VGND sg13g2_nand2_1
X_6580_ _6580_/Y _6580_/A _6587_/B VPWR VGND sg13g2_nand2_1
X_5531_ _5531_/Y _5597_/A _5597_/B _8633_/Q _5597_/D VPWR VGND sg13g2_nand4_1
X_8250_ _9125_/D _8286_/A1 _8050_/Y _8249_/Y VPWR VGND sg13g2_o21ai_1
Xoutput2712 master_wdata_o[22] _5768_/Y VPWR VGND sg13g2_buf_1
Xoutput2701 master_wdata_o[12] _5731_/Y VPWR VGND sg13g2_buf_1
Xoutput2723 master_wdata_o[3] _5712_/X VPWR VGND sg13g2_buf_1
X_7201_ _7201_/Y _7201_/A _7210_/D _7221_/C _7221_/D VPWR VGND sg13g2_nand4_1
X_5462_ _8689_/D _5462_/A _5468_/B_N VPWR VGND sg13g2_nor2b_1
X_5393_ _5395_/B _5414_/A _5414_/B VPWR VGND sg13g2_and2_1
X_8181_ _8181_/Y _8181_/A _8197_/B VPWR VGND sg13g2_nand2_1
Xoutput2734 slave_rdata_o[11] _4871_/Y VPWR VGND sg13g2_buf_1
X_4413_ _4425_/C _9223_/Q _9222_/Q _9225_/Q _9224_/Q VPWR VGND sg13g2_nor4_1
Xoutput2745 slave_rdata_o[21] _4952_/Y VPWR VGND sg13g2_buf_1
Xoutput2756 slave_rdata_o[31] _5020_/Y VPWR VGND sg13g2_buf_1
X_4344_ _4346_/A _4344_/A _4344_/B _9656_/Q VPWR VGND sg13g2_nand3_1
X_7132_ _7132_/Y _7132_/A _7132_/B _7132_/C _7132_/D VPWR VGND sg13g2_nor4_1
Xoutput2767 slave_rid_o[3] _9414_/Q VPWR VGND sg13g2_buf_1
XFILLER_101_604 VPWR VGND sg13g2_decap_8
XFILLER_99_676 VPWR VGND sg13g2_fill_1
XFILLER_86_304 VPWR VGND sg13g2_fill_1
XFILLER_59_529 VPWR VGND sg13g2_decap_8
X_7063_ _7063_/Y _5352_/C _7100_/A2 _7062_/Y VPWR VGND sg13g2_o21ai_1
XFILLER_86_337 VPWR VGND sg13g2_decap_8
X_6014_ _6014_/Y _6962_/B _8820_/D VPWR VGND sg13g2_nand2b_1
XFILLER_55_702 VPWR VGND sg13g2_decap_8
XFILLER_39_231 VPWR VGND sg13g2_fill_1
XFILLER_67_595 VPWR VGND sg13g2_decap_4
XFILLER_27_426 VPWR VGND sg13g2_decap_4
XFILLER_54_234 VPWR VGND sg13g2_decap_8
X_9704_ _9704_/Q _9708_/CLK _9704_/D fanout953/X VPWR VGND sg13g2_dfrbpq_1
X_7965_ _7965_/Y _7975_/A _8993_/Q _8365_/C VPWR VGND sg13g2_nand3_1
X_7896_ _7896_/Y _7904_/A _8963_/Q _8361_/C VPWR VGND sg13g2_nand3_1
XFILLER_23_632 VPWR VGND sg13g2_decap_4
X_6916_ _6917_/B _9628_/Q _6939_/B _9708_/Q VPWR VGND sg13g2_nand3b_1
X_6847_ _6847_/X _8897_/Q _8929_/Q _9255_/Q VPWR VGND sg13g2_mux2_1
X_9635_ _9635_/Q _9686_/CLK _9635_/D fanout969/X VPWR VGND sg13g2_dfrbpq_1
XFILLER_50_440 VPWR VGND sg13g2_fill_2
X_6778_ _9537_/D _9537_/Q _9447_/Q _6786_/S VPWR VGND sg13g2_mux2_1
X_9566_ _9566_/Q _9587_/CLK _9566_/D _9566_/RESET_B VPWR VGND sg13g2_dfrbpq_1
XFILLER_22_153 VPWR VGND sg13g2_decap_8
X_5729_ _5729_/Y _5735_/A _5735_/B _9310_/Q _5735_/D VPWR VGND sg13g2_nand4_1
X_8517_ _8517_/Y _8536_/B _8517_/B _8517_/C VPWR VGND sg13g2_nand3_1
X_9497_ _9497_/Q _9621_/CLK _9497_/D _9497_/RESET_B VPWR VGND sg13g2_dfrbpq_1
XFILLER_6_319 VPWR VGND sg13g2_fill_1
X_8448_ _8448_/Y _8448_/A _9229_/Q _8448_/C VPWR VGND sg13g2_nand3_1
XFILLER_123_217 VPWR VGND sg13g2_decap_4
X_8379_ _8379_/Y _8411_/A _9190_/Q _8383_/C VPWR VGND sg13g2_nand3_1
XFILLER_104_486 VPWR VGND sg13g2_fill_1
XFILLER_58_584 VPWR VGND sg13g2_decap_8
XFILLER_85_392 VPWR VGND sg13g2_fill_2
XFILLER_73_521 VPWR VGND sg13g2_decap_8
XFILLER_33_418 VPWR VGND sg13g2_decap_8
XFILLER_14_632 VPWR VGND sg13g2_decap_8
XFILLER_26_94 VPWR VGND sg13g2_decap_8
XFILLER_41_484 VPWR VGND sg13g2_decap_8
XFILLER_3_21 VPWR VGND sg13g2_decap_8
XFILLER_110_423 VPWR VGND sg13g2_fill_2
XFILLER_96_624 VPWR VGND sg13g2_decap_8
XFILLER_95_123 VPWR VGND sg13g2_fill_2
XFILLER_95_156 VPWR VGND sg13g2_decap_8
XFILLER_84_808 VPWR VGND sg13g2_fill_1
XFILLER_68_359 VPWR VGND sg13g2_fill_2
XFILLER_68_348 VPWR VGND sg13g2_decap_8
XFILLER_64_510 VPWR VGND sg13g2_decap_4
XFILLER_76_392 VPWR VGND sg13g2_decap_4
XFILLER_64_587 VPWR VGND sg13g2_decap_8
XFILLER_52_727 VPWR VGND sg13g2_fill_1
XFILLER_37_779 VPWR VGND sg13g2_decap_8
X_7750_ _7753_/B _7744_/Y _7749_/Y _8095_/D VPWR VGND sg13g2_o21ai_1
XFILLER_51_215 VPWR VGND sg13g2_decap_4
XFILLER_17_481 VPWR VGND sg13g2_fill_2
X_4962_ _4962_/Y _4998_/B _4789_/Y _4842_/Y _4995_/S _4928_/C VPWR VGND sg13g2_a221oi_1
X_7681_ _7681_/Y _7681_/A _7681_/B VPWR VGND sg13g2_nand2_1
X_6701_ _9469_/D _9510_/Q _9469_/Q _6702_/S VPWR VGND sg13g2_mux2_1
X_4893_ _4893_/Y _4944_/A _9358_/Q VPWR VGND sg13g2_nand2b_1
X_6632_ _6632_/Y _6642_/C _8643_/Q _9575_/Q _6655_/B2 VPWR VGND sg13g2_a22oi_1
XFILLER_60_771 VPWR VGND sg13g2_fill_2
X_9420_ _9420_/Q _9511_/CLK _9420_/D fanout958/X VPWR VGND sg13g2_dfrbpq_1
XFILLER_80_0 VPWR VGND sg13g2_decap_8
X_6563_ _6569_/D _6566_/A _6948_/B _6569_/B VPWR VGND sg13g2_o21ai_1
X_9351_ _9351_/Q _9414_/CLK _9351_/D place2503/X VPWR VGND sg13g2_dfrbpq_1
XFILLER_118_545 VPWR VGND sg13g2_decap_4
X_9282_ _9282_/Q _9305_/CLK _9282_/D place2419/X VPWR VGND sg13g2_dfrbpq_1
XFILLER_106_707 VPWR VGND sg13g2_decap_8
X_5514_ _5514_/Y _9424_/Q _5615_/B _5523_/B1 _8626_/Q VPWR VGND sg13g2_a22oi_1
X_6494_ _6494_/Y _6492_/Y _6493_/Y _6455_/A VPWR VGND sg13g2_a21oi_1
X_8302_ _9151_/D _8350_/A1 _7902_/Y _8301_/Y VPWR VGND sg13g2_o21ai_1
XFILLER_105_206 VPWR VGND sg13g2_decap_8
X_8233_ _8233_/Y _8233_/A _8243_/B VPWR VGND sg13g2_nand2_1
X_5445_ _5446_/A _5455_/A1 _8681_/Q _8682_/Q _5451_/B2 VPWR VGND sg13g2_a22oi_1
X_8164_ _9082_/D _8164_/A1 _7957_/Y _8163_/Y VPWR VGND sg13g2_o21ai_1
XFILLER_114_773 VPWR VGND sg13g2_decap_8
X_5376_ _5376_/Y _7244_/D _5376_/B _7775_/D VPWR VGND sg13g2_nor3_1
X_7115_ _7115_/Y _5369_/C _7127_/A2 _7114_/Y VPWR VGND sg13g2_o21ai_1
XFILLER_113_272 VPWR VGND sg13g2_fill_1
X_4327_ _7729_/B _9882_/A VPWR VGND sg13g2_inv_1
X_8095_ _8095_/Y _8399_/C _9498_/Q _8095_/C _8095_/D VPWR VGND sg13g2_nand4_1
XFILLER_86_145 VPWR VGND sg13g2_decap_8
X_7046_ _7046_/Y _8029_/D _6966_/Y _7036_/X _4436_/C VPWR VGND sg13g2_a22oi_1
XFILLER_47_38 VPWR VGND sg13g2_decap_8
XFILLER_103_22 VPWR VGND sg13g2_decap_8
XFILLER_28_746 VPWR VGND sg13g2_fill_1
XFILLER_82_362 VPWR VGND sg13g2_fill_2
XFILLER_82_340 VPWR VGND sg13g2_fill_2
XFILLER_70_502 VPWR VGND sg13g2_decap_4
XFILLER_55_554 VPWR VGND sg13g2_decap_8
X_8997_ _8997_/Q _9183_/CLK _8997_/D place2483/X VPWR VGND sg13g2_dfrbpq_1
XFILLER_28_779 VPWR VGND sg13g2_fill_2
XFILLER_70_546 VPWR VGND sg13g2_fill_1
X_7948_ _7948_/Y _7948_/A _8986_/Q _8399_/C VPWR VGND sg13g2_nand3_1
XFILLER_63_48 VPWR VGND sg13g2_decap_4
X_7879_ _8952_/D _8952_/Q _7735_/Y _7883_/S VPWR VGND sg13g2_mux2_1
X_9618_ _9618_/Q _9620_/CLK _9618_/D _9618_/RESET_B VPWR VGND sg13g2_dfrbpq_1
XFILLER_50_281 VPWR VGND sg13g2_decap_8
X_9549_ _9549_/Q _9672_/CLK _9549_/D place2441/X VPWR VGND sg13g2_dfrbpq_1
XFILLER_109_556 VPWR VGND sg13g2_fill_2
XFILLER_88_67 VPWR VGND sg13g2_fill_2
XFILLER_78_646 VPWR VGND sg13g2_decap_4
XFILLER_66_808 VPWR VGND sg13g2_fill_1
XFILLER_46_510 VPWR VGND sg13g2_fill_1
XFILLER_37_60 VPWR VGND sg13g2_decap_8
XFILLER_46_521 VPWR VGND sg13g2_decap_8
XFILLER_73_351 VPWR VGND sg13g2_fill_2
XFILLER_73_395 VPWR VGND sg13g2_fill_1
XFILLER_18_278 VPWR VGND sg13g2_decap_8
XFILLER_33_226 VPWR VGND sg13g2_fill_1
XFILLER_61_557 VPWR VGND sg13g2_fill_1
XFILLER_42_760 VPWR VGND sg13g2_decap_8
XFILLER_14_484 VPWR VGND sg13g2_fill_1
XFILLER_41_292 VPWR VGND sg13g2_decap_4
Xplace2529 _6440_/S1 _6514_/S1 VPWR VGND sg13g2_buf_1
Xplace2507 place2507/X place2507/A VPWR VGND sg13g2_buf_1
Xplace2518 _6421_/S0 _6302_/S0 VPWR VGND sg13g2_buf_1
Xplace1806 _8432_/A _8430_/A VPWR VGND sg13g2_buf_1
Xplace1817 _8197_/B _8225_/B VPWR VGND sg13g2_buf_1
Xplace1839 _7946_/A _7950_/A VPWR VGND sg13g2_buf_1
X_5230_ _5230_/Y _5230_/A _5233_/A VPWR VGND sg13g2_nand2_1
XFILLER_6_683 VPWR VGND sg13g2_fill_1
Xplace1828 _8055_/B _8094_/B VPWR VGND sg13g2_buf_1
Xhold3209 _8026_/A _9023_/Q VPWR VGND sg13g2_dlygate4sd3_1
X_5161_ _5169_/A _5187_/C _5159_/Y _5157_/Y VPWR VGND sg13g2_a21oi_1
XFILLER_69_624 VPWR VGND sg13g2_decap_4
XFILLER_111_743 VPWR VGND sg13g2_decap_8
XFILLER_68_145 VPWR VGND sg13g2_fill_1
X_5092_ _7889_/D _8355_/C _9472_/Q VPWR VGND sg13g2_and2_1
X_8920_ _8920_/Q _9615_/CLK _8920_/D place2417/X VPWR VGND sg13g2_dfrbpq_1
XFILLER_96_465 VPWR VGND sg13g2_decap_8
XFILLER_83_115 VPWR VGND sg13g2_decap_8
XFILLER_110_297 VPWR VGND sg13g2_fill_2
XFILLER_110_286 VPWR VGND sg13g2_fill_1
XFILLER_83_148 VPWR VGND sg13g2_fill_1
X_8851_ _8851_/Q _9253_/CLK _8851_/D place2479/X VPWR VGND sg13g2_dfrbpq_1
X_5994_ _9333_/D _5993_/Y _9333_/Q _6003_/S VPWR VGND sg13g2_mux2_1
X_8782_ _9888_/A _9260_/CLK _8782_/D place2394/X VPWR VGND sg13g2_dfrbpq_1
X_7802_ _7806_/A _7803_/A _9142_/Q _7802_/C VPWR VGND sg13g2_nor3_1
XFILLER_52_535 VPWR VGND sg13g2_fill_1
XFILLER_25_738 VPWR VGND sg13g2_fill_2
XFILLER_37_587 VPWR VGND sg13g2_fill_2
X_7733_ _7733_/Y _7733_/A _7733_/B _7733_/C _7733_/D VPWR VGND sg13g2_nand4_1
XFILLER_24_259 VPWR VGND sg13g2_decap_4
X_4945_ _4946_/C _4945_/A _4945_/B _4945_/C VPWR VGND sg13g2_or3_1
X_4876_ _4876_/Y _5017_/A1 _4874_/Y _4875_/Y VPWR VGND sg13g2_o21ai_1
X_7664_ _7664_/X _7718_/A _7839_/B _8980_/Q VPWR VGND sg13g2_or3_1
X_6615_ _6615_/Y _6622_/C _8638_/Q _9570_/Q _6669_/B2 VPWR VGND sg13g2_a22oi_1
X_7595_ _7595_/Y _7595_/A _7595_/B _7595_/C VPWR VGND sg13g2_nand3_1
X_9403_ _9403_/Q _9407_/CLK _9403_/D place2460/X VPWR VGND sg13g2_dfrbpq_1
X_9334_ _9334_/Q _9409_/CLK _9334_/D place2399/X VPWR VGND sg13g2_dfrbpq_1
X_6546_ _6546_/Y _6566_/A _6948_/B _9634_/Q _6546_/D VPWR VGND sg13g2_nor4_1
XFILLER_3_108 VPWR VGND sg13g2_fill_2
X_9265_ _9265_/Q _9410_/CLK _9265_/D place2406/X VPWR VGND sg13g2_dfrbpq_1
X_6477_ _6477_/Y _6371_/A _6371_/B _6477_/B1 VPWR VGND sg13g2_o21ai_1
X_8216_ _9108_/D _8222_/A1 _8089_/Y _8215_/Y VPWR VGND sg13g2_o21ai_1
X_5428_ _5428_/Y _8669_/Q _5434_/B VPWR VGND sg13g2_nor2_1
X_9196_ _9196_/Q clkload7/A _9196_/D place2458/X VPWR VGND sg13g2_dfrbpq_1
XFILLER_99_281 VPWR VGND sg13g2_fill_2
X_8147_ _8147_/Y _8147_/A _8159_/B VPWR VGND sg13g2_nand2_1
X_5359_ _8799_/D _5366_/A _5366_/B _5359_/C _5366_/D VPWR VGND sg13g2_nor4_1
XFILLER_58_37 VPWR VGND sg13g2_decap_8
XFILLER_102_765 VPWR VGND sg13g2_fill_1
XFILLER_59_123 VPWR VGND sg13g2_decap_8
X_8078_ _9042_/D _8098_/A1 _8077_/Y _8076_/Y VPWR VGND sg13g2_o21ai_1
XFILLER_87_465 VPWR VGND sg13g2_decap_8
XFILLER_75_605 VPWR VGND sg13g2_decap_8
X_7029_ _8345_/B _7029_/A _7029_/B VPWR VGND sg13g2_nor2_1
XFILLER_47_318 VPWR VGND sg13g2_decap_8
XFILLER_87_498 VPWR VGND sg13g2_decap_4
XFILLER_75_649 VPWR VGND sg13g2_fill_1
XFILLER_74_148 VPWR VGND sg13g2_fill_1
XFILLER_114_98 VPWR VGND sg13g2_fill_2
XFILLER_90_608 VPWR VGND sg13g2_decap_4
XFILLER_83_660 VPWR VGND sg13g2_fill_1
XFILLER_74_36 VPWR VGND sg13g2_fill_1
XFILLER_83_671 VPWR VGND sg13g2_fill_2
XFILLER_70_398 VPWR VGND sg13g2_fill_2
XFILLER_11_421 VPWR VGND sg13g2_decap_8
XFILLER_23_270 VPWR VGND sg13g2_decap_8
XFILLER_23_281 VPWR VGND sg13g2_fill_2
XFILLER_23_292 VPWR VGND sg13g2_fill_2
XFILLER_39_808 VPWR VGND sg13g2_fill_1
XFILLER_78_476 VPWR VGND sg13g2_decap_8
XFILLER_66_616 VPWR VGND sg13g2_fill_2
XFILLER_120_584 VPWR VGND sg13g2_decap_8
XFILLER_19_532 VPWR VGND sg13g2_decap_8
XFILLER_93_468 VPWR VGND sg13g2_decap_8
XFILLER_93_457 VPWR VGND sg13g2_decap_8
XFILLER_19_554 VPWR VGND sg13g2_fill_2
XFILLER_0_77 VPWR VGND sg13g2_decap_8
XFILLER_0_88 VPWR VGND sg13g2_fill_1
Xclkbuf_leaf_0_jtag_tck_i_regs _9708_/CLK clkbuf_leaf_1_jtag_tck_i_regs/A VPWR VGND
+ sg13g2_buf_16
X_4730_ _4730_/Y _9688_/Q _8742_/Q _6956_/S _4724_/Y VPWR VGND sg13g2_a22oi_1
XFILLER_9_42 VPWR VGND sg13g2_decap_8
XFILLER_14_270 VPWR VGND sg13g2_fill_1
XFILLER_15_793 VPWR VGND sg13g2_decap_4
X_4661_ _4661_/Y _8717_/Q _9644_/Q VPWR VGND sg13g2_nor2b_1
X_7380_ _7384_/D _9152_/Q _7385_/B _7389_/A VPWR VGND sg13g2_o21ai_1
Xplace2304 _4776_/B _9338_/Q VPWR VGND sg13g2_buf_1
X_6400_ _6400_/X _9002_/Q _9064_/Q _9126_/Q _9188_/Q _6400_/S0 _6400_/S1 VPWR VGND
+ sg13g2_mux4_1
Xplace2315 _6909_/S _6877_/S VPWR VGND sg13g2_buf_1
X_6331_ _6331_/X _8825_/Q _8827_/Q _8829_/Q _8831_/Q _6514_/S0 _6514_/S1 VPWR VGND
+ sg13g2_mux4_1
Xplace2326 _4855_/A _8818_/Q VPWR VGND sg13g2_buf_1
X_4592_ _9695_/D _4743_/A _4592_/B VPWR VGND sg13g2_nor2_1
Xplace2337 _4880_/B _8817_/Q VPWR VGND sg13g2_buf_1
Xplace2359 _8534_/A _8517_/C VPWR VGND sg13g2_buf_1
Xplace2348 _8089_/A _8414_/C VPWR VGND sg13g2_buf_1
XFILLER_88_207 VPWR VGND sg13g2_decap_4
Xhold3006 _4705_/A _8739_/Q VPWR VGND sg13g2_dlygate4sd3_1
X_6262_ _6264_/B _6262_/A _6262_/B _6262_/C _6262_/D VPWR VGND sg13g2_nand4_1
X_9050_ _9050_/Q _9188_/CLK _9050_/D place2465/X VPWR VGND sg13g2_dfrbpq_1
XFILLER_115_378 VPWR VGND sg13g2_fill_1
X_5213_ _8763_/D _5274_/B2 _5355_/C _5212_/Y VPWR VGND sg13g2_o21ai_1
Xhold3028 _8133_/A _9067_/Q VPWR VGND sg13g2_dlygate4sd3_1
Xhold3039 _8031_/A _9025_/Q VPWR VGND sg13g2_dlygate4sd3_1
Xhold3017 _8109_/A _9055_/Q VPWR VGND sg13g2_dlygate4sd3_1
X_6193_ _6193_/Y _6325_/A1 _6192_/Y _6332_/B VPWR VGND sg13g2_o21ai_1
X_8001_ _8001_/Y _8007_/A _9011_/Q _8411_/C VPWR VGND sg13g2_nand3_1
X_5144_ _5349_/C _8407_/C _9476_/Q VPWR VGND sg13g2_nand2_1
X_5075_ _5075_/X _7775_/C _5827_/A _7006_/C _8563_/C VPWR VGND sg13g2_or4_1
XFILLER_84_435 VPWR VGND sg13g2_decap_8
X_9883_ _9883_/X _9883_/A VPWR VGND sg13g2_buf_1
XFILLER_84_457 VPWR VGND sg13g2_fill_2
X_8903_ _8903_/Q _9620_/CLK _8903_/D place2438/X VPWR VGND sg13g2_dfrbpq_1
X_8834_ _8834_/Q _9692_/CLK _8834_/D place2496/X VPWR VGND sg13g2_dfrbpq_1
XFILLER_25_524 VPWR VGND sg13g2_decap_8
XFILLER_52_343 VPWR VGND sg13g2_decap_4
X_5977_ _5977_/Y _9493_/Q _5980_/A2 _5881_/X _5980_/B2 VPWR VGND sg13g2_a22oi_1
X_8765_ _9871_/A _9252_/CLK _8765_/D place2391/X VPWR VGND sg13g2_dfrbpq_1
X_7716_ _7716_/Y _7811_/A _7811_/B _7811_/C _7716_/D VPWR VGND sg13g2_nor4_1
X_8696_ _8696_/Q _9630_/CLK _8696_/D fanout955/X VPWR VGND sg13g2_dfrbpq_1
XFILLER_21_730 VPWR VGND sg13g2_decap_8
XFILLER_21_741 VPWR VGND sg13g2_fill_1
X_4928_ _5012_/D _4945_/A _4928_/B _4928_/C VPWR VGND sg13g2_nand3_1
XFILLER_100_67 VPWR VGND sg13g2_decap_8
X_7647_ _7647_/Y _7785_/A _7647_/B _7647_/C _7647_/D VPWR VGND sg13g2_nor4_1
XFILLER_121_7 VPWR VGND sg13g2_decap_8
X_4859_ _4859_/Y _4798_/Y _4858_/Y _4855_/Y VPWR VGND sg13g2_a21oi_1
XFILLER_119_651 VPWR VGND sg13g2_decap_8
XFILLER_109_10 VPWR VGND sg13g2_decap_4
X_7578_ _7581_/A _9291_/Q _7796_/A2 _7796_/B1 _9323_/Q VPWR VGND sg13g2_a22oi_1
X_9317_ _9317_/Q _9409_/CLK _9317_/D place2393/X VPWR VGND sg13g2_dfrbpq_1
X_6529_ _6535_/S _6524_/Y _6528_/Y _6521_/Y VPWR VGND sg13g2_o21ai_1
XFILLER_109_87 VPWR VGND sg13g2_fill_2
X_9248_ _9248_/Q _9251_/CLK _9248_/D place2478/X VPWR VGND sg13g2_dfrbpq_1
XFILLER_88_752 VPWR VGND sg13g2_fill_2
XFILLER_0_623 VPWR VGND sg13g2_decap_4
X_9179_ _9179_/Q _9183_/CLK _9179_/D place2484/X VPWR VGND sg13g2_dfrbpq_1
XFILLER_102_573 VPWR VGND sg13g2_fill_2
XFILLER_88_774 VPWR VGND sg13g2_fill_2
XFILLER_85_68 VPWR VGND sg13g2_decap_8
XFILLER_75_468 VPWR VGND sg13g2_decap_8
XFILLER_90_438 VPWR VGND sg13g2_fill_1
XFILLER_90_427 VPWR VGND sg13g2_decap_8
XFILLER_62_107 VPWR VGND sg13g2_fill_1
XFILLER_28_362 VPWR VGND sg13g2_fill_2
XFILLER_43_310 VPWR VGND sg13g2_fill_2
XFILLER_55_181 VPWR VGND sg13g2_decap_8
XFILLER_31_538 VPWR VGND sg13g2_decap_4
XFILLER_8_712 VPWR VGND sg13g2_decap_4
XFILLER_12_774 VPWR VGND sg13g2_decap_4
XFILLER_34_94 VPWR VGND sg13g2_fill_1
XFILLER_59_80 VPWR VGND sg13g2_decap_4
XFILLER_120_370 VPWR VGND sg13g2_decap_8
XFILLER_78_295 VPWR VGND sg13g2_fill_1
XFILLER_39_638 VPWR VGND sg13g2_decap_8
XFILLER_66_457 VPWR VGND sg13g2_decap_8
X_5900_ _5901_/B _5954_/A _5932_/B _5983_/A _5924_/D VPWR VGND sg13g2_nand4_1
XFILLER_93_276 VPWR VGND sg13g2_decap_8
XFILLER_47_671 VPWR VGND sg13g2_decap_8
X_6880_ _9606_/D _6879_/X _9606_/Q _6910_/S VPWR VGND sg13g2_mux2_1
X_5831_ _5831_/X _5983_/A _5899_/A1 _5945_/A VPWR VGND sg13g2_mux2_1
XFILLER_61_162 VPWR VGND sg13g2_fill_2
X_8550_ _8551_/A _9268_/Q _8560_/A2 _8560_/B1 _9494_/Q VPWR VGND sg13g2_a22oi_1
X_5762_ _5762_/Y _5762_/A1 _5906_/A2 _5085_/Y _9319_/Q VPWR VGND sg13g2_a22oi_1
XFILLER_61_184 VPWR VGND sg13g2_decap_4
XFILLER_61_173 VPWR VGND sg13g2_fill_1
X_7501_ _7515_/D _9287_/Q _7843_/A2 _7843_/B1 _9319_/Q VPWR VGND sg13g2_a22oi_1
X_4713_ _4714_/C _8741_/Q _4713_/B VPWR VGND sg13g2_nor2_1
X_5693_ _5694_/A _8601_/Q _5693_/A2 _5693_/B1 _5693_/B2 VPWR VGND sg13g2_a22oi_1
XFILLER_30_560 VPWR VGND sg13g2_decap_8
XFILLER_30_571 VPWR VGND sg13g2_decap_8
X_8481_ _9245_/D _8492_/A _5360_/C _8480_/Y VPWR VGND sg13g2_o21ai_1
X_4644_ _4692_/B _9551_/Q _9552_/Q VPWR VGND sg13g2_nand2_1
X_7432_ _7433_/C _9867_/A _7825_/A2 _7825_/B1 _7432_/B2 VPWR VGND sg13g2_a22oi_1
Xplace2101 _7491_/B _7816_/B VPWR VGND sg13g2_buf_1
Xplace2112 _8056_/D _8068_/D VPWR VGND sg13g2_buf_1
Xplace2145 _5938_/A _5050_/Y VPWR VGND sg13g2_buf_1
Xplace2134 _8483_/A2 _5361_/C VPWR VGND sg13g2_buf_1
X_7363_ _7366_/B _7369_/C _9120_/Q _7387_/C VPWR VGND sg13g2_nor3_1
X_4575_ _9705_/D _4743_/A _4579_/B VPWR VGND sg13g2_nor2b_1
Xplace2123 _8130_/A1 _7017_/Y VPWR VGND sg13g2_buf_1
XFILLER_116_643 VPWR VGND sg13g2_decap_8
XFILLER_115_120 VPWR VGND sg13g2_decap_4
X_9102_ _9102_/Q _9304_/CLK _9102_/D place2413/X VPWR VGND sg13g2_dfrbpq_1
Xplace2189 _8563_/A _7029_/A VPWR VGND sg13g2_buf_1
Xplace2167 _5597_/D _5525_/D VPWR VGND sg13g2_buf_1
X_6314_ _9372_/D _6308_/Y _6312_/X _6313_/Y VPWR VGND sg13g2_a21oi_1
Xplace2178 _7295_/C _7490_/C VPWR VGND sg13g2_buf_1
X_7294_ _7294_/Y _7294_/A _7294_/B _7294_/C _7294_/D VPWR VGND sg13g2_nor4_1
Xplace2156 _7381_/B _4529_/Y VPWR VGND sg13g2_buf_1
XFILLER_116_687 VPWR VGND sg13g2_decap_8
XFILLER_89_538 VPWR VGND sg13g2_decap_8
XFILLER_89_516 VPWR VGND sg13g2_decap_8
X_9033_ _9033_/Q clkload8/A _9033_/D place2466/X VPWR VGND sg13g2_dfrbpq_1
X_6245_ _9365_/D _6241_/Y _6243_/Y _6244_/Y VPWR VGND sg13g2_a21oi_1
XFILLER_115_197 VPWR VGND sg13g2_decap_8
XFILLER_103_348 VPWR VGND sg13g2_decap_8
X_6176_ _6176_/Y _6176_/A _6365_/B _6365_/A _6365_/C VPWR VGND sg13g2_nand4_1
X_5127_ _5130_/B _5129_/D _5175_/B _5175_/C _5178_/A VPWR VGND sg13g2_nand4_1
XFILLER_85_744 VPWR VGND sg13g2_decap_8
X_5058_ _8530_/A _6534_/B _5070_/C _6534_/A VPWR VGND sg13g2_o21ai_1
XFILLER_85_788 VPWR VGND sg13g2_fill_2
XFILLER_57_468 VPWR VGND sg13g2_decap_8
XFILLER_45_619 VPWR VGND sg13g2_decap_8
XFILLER_55_27 VPWR VGND sg13g2_fill_2
X_9866_ _9866_/X _9866_/A VPWR VGND sg13g2_buf_1
X_8817_ _8817_/Q _9414_/CLK _8817_/D place2504/X VPWR VGND sg13g2_dfrbpq_1
XFILLER_13_505 VPWR VGND sg13g2_decap_8
XFILLER_71_37 VPWR VGND sg13g2_fill_2
X_8748_ _8748_/Q _9253_/CLK _8748_/D place2487/X VPWR VGND sg13g2_dfrbpq_1
XFILLER_13_527 VPWR VGND sg13g2_decap_8
X_9505__2875 _9505_/RESET_B VPWR VGND sg13g2_tiehi
XFILLER_71_59 VPWR VGND sg13g2_fill_2
XFILLER_71_48 VPWR VGND sg13g2_fill_2
X_8679_ _8679_/Q _9630_/CLK _8679_/D fanout943/X VPWR VGND sg13g2_dfrbpq_1
XFILLER_21_582 VPWR VGND sg13g2_decap_8
XFILLER_119_470 VPWR VGND sg13g2_decap_8
XFILLER_4_247 VPWR VGND sg13g2_decap_8
XFILLER_107_676 VPWR VGND sg13g2_fill_1
XFILLER_106_164 VPWR VGND sg13g2_fill_1
XFILLER_106_153 VPWR VGND sg13g2_decap_8
XFILLER_0_431 VPWR VGND sg13g2_decap_8
XFILLER_122_668 VPWR VGND sg13g2_fill_2
XFILLER_110_808 VPWR VGND sg13g2_fill_1
XFILLER_48_435 VPWR VGND sg13g2_fill_1
XFILLER_75_276 VPWR VGND sg13g2_decap_8
XFILLER_35_107 VPWR VGND sg13g2_decap_4
XFILLER_56_490 VPWR VGND sg13g2_fill_2
XFILLER_16_310 VPWR VGND sg13g2_fill_2
XFILLER_44_630 VPWR VGND sg13g2_decap_8
XFILLER_71_460 VPWR VGND sg13g2_fill_1
XFILLER_84_7 VPWR VGND sg13g2_decap_8
Xinput2590 _5931_/A1 master_rdata_i[20] VPWR VGND sg13g2_buf_1
XFILLER_8_586 VPWR VGND sg13g2_fill_2
XFILLER_6_21 VPWR VGND sg13g2_decap_8
X_4360_ _9681_/D _4467_/A _4358_/B _4359_/Y VPWR VGND sg13g2_o21ai_1
XFILLER_113_613 VPWR VGND sg13g2_decap_8
XFILLER_86_508 VPWR VGND sg13g2_decap_8
X_6030_ _6031_/C _6037_/A _6041_/A _6037_/C _6043_/B VPWR VGND sg13g2_nor4_1
XFILLER_94_596 VPWR VGND sg13g2_decap_8
XFILLER_26_118 VPWR VGND sg13g2_fill_2
X_7981_ _7981_/Y _7985_/A _9001_/Q _8409_/C VPWR VGND sg13g2_nand3_1
XFILLER_82_769 VPWR VGND sg13g2_fill_1
XFILLER_54_438 VPWR VGND sg13g2_fill_1
XFILLER_19_192 VPWR VGND sg13g2_decap_8
X_6932_ _6932_/X _9629_/Q _6937_/B _6939_/C VPWR VGND sg13g2_and3_1
XFILLER_26_129 VPWR VGND sg13g2_fill_2
X_9651_ _9651_/Q _9662_/CLK _9651_/D place2446/X VPWR VGND sg13g2_dfrbpq_1
X_6863_ _6863_/X _8905_/Q _8937_/Q _6909_/S VPWR VGND sg13g2_mux2_1
X_5814_ _5815_/A _9300_/Q _5786_/Y _5787_/Y _9497_/Q VPWR VGND sg13g2_a22oi_1
XFILLER_22_302 VPWR VGND sg13g2_decap_8
X_8602_ _8602_/Q _9708_/CLK _8602_/D fanout950/X VPWR VGND sg13g2_dfrbpq_1
X_9582_ _9582_/Q _9582_/CLK _9582_/D _9582_/RESET_B VPWR VGND sg13g2_dfrbpq_1
X_6794_ _9549_/D _9551_/Q _4691_/X _6793_/Y VPWR VGND sg13g2_o21ai_1
X_5745_ _5745_/Y _9323_/Q _5765_/B VPWR VGND sg13g2_nand2b_1
X_8533_ _8544_/B _8563_/A _8533_/B VPWR VGND sg13g2_nor2_1
XFILLER_50_688 VPWR VGND sg13g2_decap_8
X_5676_ _8591_/D _5676_/A VPWR VGND sg13g2_inv_1
X_8464_ _8464_/Y _8476_/A _8464_/B _8490_/C VPWR VGND sg13g2_nand3_1
X_4627_ _4652_/A _9638_/Q _6742_/D VPWR VGND sg13g2_nor2_1
X_7415_ _7416_/C _8792_/Q _7301_/B _5383_/Y _9866_/A VPWR VGND sg13g2_a22oi_1
X_8395_ _8395_/Y _8401_/A _9198_/Q _8401_/C VPWR VGND sg13g2_nand3_1
XFILLER_116_451 VPWR VGND sg13g2_decap_8
X_4558_ _4558_/Y _9212_/Q _5826_/A VPWR VGND sg13g2_nand2b_1
X_7346_ _7348_/B _7351_/C _7351_/B _9088_/Q VPWR VGND sg13g2_nor3_1
XFILLER_116_495 VPWR VGND sg13g2_decap_4
XFILLER_116_484 VPWR VGND sg13g2_fill_1
X_4489_ _9639_/D _4666_/A _4489_/B VPWR VGND sg13g2_nor2_1
X_7277_ _7280_/C _9022_/Q _7291_/B VPWR VGND sg13g2_nor2_1
XFILLER_104_679 VPWR VGND sg13g2_decap_4
XFILLER_103_167 VPWR VGND sg13g2_fill_2
X_9016_ _9016_/Q _9504_/CLK _9016_/D place2432/X VPWR VGND sg13g2_dfrbpq_1
X_6228_ _6229_/A _6113_/Y _6227_/Y _6176_/A VPWR VGND sg13g2_o21ai_1
X_6159_ _6160_/D _6322_/B _6237_/B _9233_/Q _8474_/B VPWR VGND sg13g2_and4_1
XFILLER_122_21 VPWR VGND sg13g2_decap_8
XFILLER_82_25 VPWR VGND sg13g2_fill_1
XFILLER_72_257 VPWR VGND sg13g2_fill_2
XFILLER_41_600 VPWR VGND sg13g2_decap_4
XFILLER_25_184 VPWR VGND sg13g2_fill_2
XFILLER_26_685 VPWR VGND sg13g2_fill_1
XFILLER_13_346 VPWR VGND sg13g2_decap_4
XFILLER_41_677 VPWR VGND sg13g2_decap_8
XFILLER_21_390 VPWR VGND sg13g2_decap_8
XFILLER_5_523 VPWR VGND sg13g2_decap_4
XFILLER_110_0 VPWR VGND sg13g2_decap_8
XFILLER_5_578 VPWR VGND sg13g2_decap_8
XFILLER_122_421 VPWR VGND sg13g2_fill_1
XFILLER_107_495 VPWR VGND sg13g2_fill_2
XFILLER_49_722 VPWR VGND sg13g2_decap_8
XFILLER_49_777 VPWR VGND sg13g2_fill_1
XFILLER_49_755 VPWR VGND sg13g2_fill_2
XFILLER_0_283 VPWR VGND sg13g2_fill_2
XFILLER_76_596 VPWR VGND sg13g2_decap_8
XFILLER_64_736 VPWR VGND sg13g2_decap_8
XFILLER_64_725 VPWR VGND sg13g2_decap_8
XFILLER_49_799 VPWR VGND sg13g2_fill_2
XFILLER_36_405 VPWR VGND sg13g2_decap_4
XFILLER_48_265 VPWR VGND sg13g2_fill_2
XFILLER_63_235 VPWR VGND sg13g2_decap_8
XFILLER_16_184 VPWR VGND sg13g2_fill_1
XFILLER_17_696 VPWR VGND sg13g2_decap_4
X_5530_ _8631_/D _5529_/Y _5528_/Y _5602_/B1 VPWR VGND sg13g2_a21oi_1
X_5461_ _5462_/A _5469_/A1 _8689_/Q _8690_/Q _5467_/B2 VPWR VGND sg13g2_a22oi_1
X_9609__2781 _9609_/RESET_B VPWR VGND sg13g2_tiehi
XFILLER_117_237 VPWR VGND sg13g2_fill_1
Xoutput2713 master_wdata_o[23] _5772_/Y VPWR VGND sg13g2_buf_1
Xoutput2702 master_wdata_o[13] _5734_/Y VPWR VGND sg13g2_buf_1
X_7200_ _8883_/D _7199_/Y _8883_/Q _7213_/S VPWR VGND sg13g2_mux2_1
XFILLER_8_383 VPWR VGND sg13g2_fill_2
X_4412_ _4425_/B _9227_/Q _9226_/Q _9229_/Q _9228_/Q VPWR VGND sg13g2_nor4_1
Xoutput2724 master_wdata_o[4] _5713_/X VPWR VGND sg13g2_buf_1
Xoutput2746 slave_rdata_o[22] _4960_/Y VPWR VGND sg13g2_buf_1
X_5392_ _5414_/B _6037_/A _6018_/B _5392_/C _5392_/D VPWR VGND sg13g2_nand4_1
X_8180_ _9090_/D _8198_/A1 _8039_/Y _8179_/Y VPWR VGND sg13g2_o21ai_1
Xoutput2757 slave_rdata_o[3] _4788_/Y VPWR VGND sg13g2_buf_1
Xoutput2735 slave_rdata_o[12] _4882_/Y VPWR VGND sg13g2_buf_1
X_4343_ _4344_/A _9662_/Q _9661_/Q VPWR VGND sg13g2_nor2_1
XFILLER_113_432 VPWR VGND sg13g2_decap_8
X_7131_ _8863_/D _7130_/Y _8863_/Q _7131_/S VPWR VGND sg13g2_mux2_1
Xoutput2768 slave_rvalid_o _8820_/Q VPWR VGND sg13g2_buf_1
XFILLER_87_806 VPWR VGND sg13g2_fill_2
XFILLER_59_508 VPWR VGND sg13g2_decap_8
X_7062_ _7062_/Y _7158_/A _7182_/D _7080_/C VPWR VGND sg13g2_nand3_1
XFILLER_100_115 VPWR VGND sg13g2_fill_1
X_6013_ _9343_/D _6071_/A _6013_/B VPWR VGND sg13g2_nor2_1
XFILLER_79_390 VPWR VGND sg13g2_decap_8
XFILLER_67_541 VPWR VGND sg13g2_decap_8
XFILLER_39_221 VPWR VGND sg13g2_fill_1
XFILLER_39_243 VPWR VGND sg13g2_fill_1
XFILLER_39_265 VPWR VGND sg13g2_decap_8
X_7964_ _8992_/D _5346_/C _7979_/A _7963_/Y VPWR VGND sg13g2_o21ai_1
XFILLER_82_588 VPWR VGND sg13g2_decap_8
XFILLER_54_279 VPWR VGND sg13g2_decap_8
X_9703_ _9703_/Q _9708_/CLK _9703_/D fanout953/X VPWR VGND sg13g2_dfrbpq_1
X_6915_ _6917_/A _6915_/A _6915_/B VPWR VGND sg13g2_nand2_1
XFILLER_82_599 VPWR VGND sg13g2_fill_2
XFILLER_70_739 VPWR VGND sg13g2_decap_8
X_7895_ _8962_/D _5347_/C _7904_/A _7894_/Y VPWR VGND sg13g2_o21ai_1
X_6846_ _9589_/D _6845_/X _9589_/Q _6904_/S VPWR VGND sg13g2_mux2_1
X_9634_ _9634_/Q _9686_/CLK _9634_/D fanout969/X VPWR VGND sg13g2_dfrbpq_1
X_6777_ _9536_/D _9536_/Q _9446_/Q _6781_/S VPWR VGND sg13g2_mux2_1
X_9565_ _9565_/Q _9588_/CLK _9565_/D _9565_/RESET_B VPWR VGND sg13g2_dfrbpq_1
XFILLER_50_474 VPWR VGND sg13g2_decap_4
XFILLER_109_705 VPWR VGND sg13g2_fill_1
X_8516_ _8516_/X _8536_/B _8517_/C VPWR VGND sg13g2_and2_1
X_5728_ _5728_/Y _5762_/A1 _5740_/A2 _5726_/Y _5727_/Y VPWR VGND sg13g2_a22oi_1
X_9496_ _9496_/Q _9621_/CLK _9496_/D _9496_/RESET_B VPWR VGND sg13g2_dfrbpq_1
X_5659_ _8611_/D _5655_/Y _5659_/A2 _5657_/Y VPWR VGND sg13g2_a21oi_1
X_8447_ _9228_/D _8488_/A _5374_/C _8446_/Y VPWR VGND sg13g2_o21ai_1
XFILLER_117_760 VPWR VGND sg13g2_fill_1
X_8378_ _9189_/D _5357_/C _8409_/A _8377_/Y VPWR VGND sg13g2_o21ai_1
X_7329_ _7330_/D _9149_/Q _7385_/B VPWR VGND sg13g2_nor2_1
XFILLER_2_537 VPWR VGND sg13g2_decap_8
XFILLER_89_154 VPWR VGND sg13g2_fill_1
XFILLER_77_14 VPWR VGND sg13g2_fill_1
XFILLER_77_316 VPWR VGND sg13g2_fill_1
XFILLER_100_671 VPWR VGND sg13g2_fill_1
XFILLER_45_213 VPWR VGND sg13g2_decap_8
XFILLER_73_577 VPWR VGND sg13g2_fill_2
XFILLER_60_216 VPWR VGND sg13g2_decap_4
XFILLER_14_611 VPWR VGND sg13g2_decap_8
XFILLER_26_460 VPWR VGND sg13g2_decap_8
XFILLER_26_482 VPWR VGND sg13g2_fill_2
XFILLER_26_493 VPWR VGND sg13g2_decap_8
XFILLER_13_165 VPWR VGND sg13g2_fill_1
XFILLER_41_463 VPWR VGND sg13g2_decap_8
XFILLER_5_331 VPWR VGND sg13g2_decap_4
XFILLER_123_796 VPWR VGND sg13g2_decap_4
XFILLER_3_66 VPWR VGND sg13g2_decap_8
X_9464__2916 _9464_/RESET_B VPWR VGND sg13g2_tiehi
X_9500__2880 _9500_/RESET_B VPWR VGND sg13g2_tiehi
XFILLER_49_574 VPWR VGND sg13g2_decap_4
XFILLER_36_224 VPWR VGND sg13g2_decap_4
XFILLER_37_758 VPWR VGND sg13g2_decap_8
XFILLER_64_555 VPWR VGND sg13g2_decap_8
XFILLER_36_268 VPWR VGND sg13g2_fill_2
X_4961_ _4961_/Y _4883_/A _9367_/Q VPWR VGND sg13g2_nand2b_1
X_7680_ _7681_/B _8806_/Q _7787_/B _7680_/B1 _8886_/Q VPWR VGND sg13g2_a22oi_1
X_6700_ _9468_/D _9509_/Q _9468_/Q _6733_/S VPWR VGND sg13g2_mux2_1
X_4892_ _4892_/Y _4880_/B _4887_/Y _4891_/Y VPWR VGND sg13g2_o21ai_1
X_6631_ _6631_/Y _9441_/Q _6651_/B VPWR VGND sg13g2_nand2_1
X_9350_ _9350_/Q _9692_/CLK _9350_/D place2502/X VPWR VGND sg13g2_dfrbpq_1
XFILLER_20_636 VPWR VGND sg13g2_decap_8
XFILLER_73_0 VPWR VGND sg13g2_fill_1
X_6562_ _6569_/A _6562_/A _6951_/C VPWR VGND sg13g2_nand2_1
X_8301_ _8301_/Y _8301_/A _8349_/B VPWR VGND sg13g2_nand2_1
X_9281_ _9281_/Q _9410_/CLK _9281_/D place2405/X VPWR VGND sg13g2_dfrbpq_1
X_5513_ _5513_/Y _5525_/A _5525_/B _8627_/Q _5525_/D VPWR VGND sg13g2_nand4_1
X_6493_ _6493_/Y _9018_/Q _6506_/A2 _6507_/A2 _9204_/Q VPWR VGND sg13g2_a22oi_1
XFILLER_9_681 VPWR VGND sg13g2_fill_2
X_8232_ _9116_/D _8252_/A1 _7892_/Y _8231_/Y VPWR VGND sg13g2_o21ai_1
X_5444_ _8680_/D _5444_/A _5454_/B_N VPWR VGND sg13g2_nor2b_1
X_8163_ _8163_/Y _9082_/Q _8163_/B VPWR VGND sg13g2_nand2_1
XFILLER_113_240 VPWR VGND sg13g2_decap_8
X_5375_ _8815_/D _5375_/A _5375_/B _5375_/C _5375_/D VPWR VGND sg13g2_nor4_1
X_7114_ _7114_/Y _7218_/A _7221_/B _7129_/C VPWR VGND sg13g2_nand3_1
X_4326_ _4326_/Y _9881_/A VPWR VGND sg13g2_inv_1
X_8094_ _8094_/Y _8094_/A _8094_/B VPWR VGND sg13g2_nand2_1
XFILLER_113_284 VPWR VGND sg13g2_fill_2
XFILLER_86_135 VPWR VGND sg13g2_fill_1
XFILLER_86_124 VPWR VGND sg13g2_decap_8
X_7045_ _8835_/D _7059_/A _7043_/Y _7044_/Y VPWR VGND sg13g2_o21ai_1
XFILLER_67_371 VPWR VGND sg13g2_decap_4
XFILLER_55_577 VPWR VGND sg13g2_decap_4
X_8996_ _8996_/Q clkload8/A _8996_/D place2466/X VPWR VGND sg13g2_dfrbpq_1
X_7947_ _8985_/D _5370_/C _7946_/A _7946_/Y VPWR VGND sg13g2_o21ai_1
XFILLER_36_791 VPWR VGND sg13g2_fill_2
X_7878_ _8951_/D _8951_/Q _7716_/Y _7881_/S VPWR VGND sg13g2_mux2_1
X_6829_ _9577_/D _9610_/Q _9577_/Q _6834_/S VPWR VGND sg13g2_mux2_1
X_9617_ _9617_/Q _9621_/CLK _9617_/D _9617_/RESET_B VPWR VGND sg13g2_dfrbpq_1
XFILLER_11_614 VPWR VGND sg13g2_decap_8
XFILLER_23_452 VPWR VGND sg13g2_fill_2
X_9548_ _9548_/Q _9672_/CLK _9548_/D place2441/X VPWR VGND sg13g2_dfrbpq_1
X_9479_ _9479_/Q _9603_/CLK _9479_/D _9479_/RESET_B VPWR VGND sg13g2_dfrbpq_1
XFILLER_6_139 VPWR VGND sg13g2_decap_8
X_9542__2838 _9542_/RESET_B VPWR VGND sg13g2_tiehi
XFILLER_105_785 VPWR VGND sg13g2_decap_4
XFILLER_77_135 VPWR VGND sg13g2_fill_1
XFILLER_93_628 VPWR VGND sg13g2_fill_2
XFILLER_92_127 VPWR VGND sg13g2_fill_1
XFILLER_19_736 VPWR VGND sg13g2_decap_8
XFILLER_18_257 VPWR VGND sg13g2_decap_8
XFILLER_37_94 VPWR VGND sg13g2_decap_8
XFILLER_34_739 VPWR VGND sg13g2_fill_2
XFILLER_33_238 VPWR VGND sg13g2_fill_2
Xplace2519 _6480_/S0 _6514_/S0 VPWR VGND sg13g2_buf_1
Xplace2508 _7236_/A _7187_/A VPWR VGND sg13g2_buf_1
Xplace1807 _8403_/A _8397_/A VPWR VGND sg13g2_buf_1
X_9518__2862 _9518_/RESET_B VPWR VGND sg13g2_tiehi
Xplace1818 _8191_/B _8225_/B VPWR VGND sg13g2_buf_1
XFILLER_108_590 VPWR VGND sg13g2_fill_2
Xplace1829 _8011_/A _8003_/A VPWR VGND sg13g2_buf_1
XFILLER_123_582 VPWR VGND sg13g2_decap_8
XFILLER_123_560 VPWR VGND sg13g2_decap_8
X_5160_ _5185_/A _5177_/A _5160_/B _9864_/A VPWR VGND sg13g2_nand3_1
XFILLER_68_113 VPWR VGND sg13g2_decap_8
XFILLER_96_433 VPWR VGND sg13g2_decap_4
X_5091_ _5091_/Y _5090_/B _5065_/Y _5090_/Y VPWR VGND sg13g2_o21ai_1
XFILLER_68_124 VPWR VGND sg13g2_fill_2
XFILLER_111_777 VPWR VGND sg13g2_fill_1
XFILLER_56_319 VPWR VGND sg13g2_decap_8
X_8850_ _8850_/Q _9252_/CLK _8850_/D place2454/X VPWR VGND sg13g2_dfrbpq_1
X_5993_ _5993_/Y _6519_/A _5371_/C _5992_/Y VPWR VGND sg13g2_o21ai_1
X_8781_ _9887_/A _9260_/CLK _8781_/D place2400/X VPWR VGND sg13g2_dfrbpq_1
X_7801_ _7801_/Y _7801_/A _7801_/B _7801_/C _7801_/D VPWR VGND sg13g2_nor4_1
XFILLER_18_780 VPWR VGND sg13g2_fill_1
X_7732_ _7733_/B _9330_/Q _7826_/A2 _7794_/B1 _8888_/Q _7729_/Y VPWR VGND sg13g2_a221oi_1
XFILLER_52_558 VPWR VGND sg13g2_fill_2
X_4944_ _4944_/Y _4944_/A _9365_/Q VPWR VGND sg13g2_nor2b_1
XFILLER_60_591 VPWR VGND sg13g2_decap_8
X_7663_ _7667_/B _9073_/Q _7670_/B VPWR VGND sg13g2_nor2_1
X_9402_ _9402_/Q _9407_/CLK _9402_/D place2455/X VPWR VGND sg13g2_dfrbpq_1
X_4875_ _4875_/Y _5017_/A1 _4766_/A _4772_/A VPWR VGND sg13g2_a21oi_1
X_6614_ _6614_/Y _6614_/A _6654_/B VPWR VGND sg13g2_nand2_1
X_7594_ _7595_/C _9875_/A _7694_/B _7794_/B1 _8881_/Q VPWR VGND sg13g2_a22oi_1
XFILLER_20_466 VPWR VGND sg13g2_fill_2
X_9333_ _9333_/Q _9409_/CLK _9333_/D place2393/X VPWR VGND sg13g2_dfrbpq_1
X_6545_ _6545_/Y _6569_/B _6545_/B _6561_/B _6545_/D VPWR VGND sg13g2_nand4_1
X_9264_ _9264_/Q _9410_/CLK _9264_/D place2404/X VPWR VGND sg13g2_dfrbpq_1
X_8215_ _8215_/Y _8215_/A _8221_/B VPWR VGND sg13g2_nand2_1
X_6476_ _6476_/Y _6476_/A _6510_/B VPWR VGND sg13g2_nand2_1
X_9195_ _9195_/Q _9304_/CLK _9195_/D place2410/X VPWR VGND sg13g2_dfrbpq_1
X_5427_ _8667_/D _5427_/A _5472_/B_N VPWR VGND sg13g2_nor2b_1
XFILLER_102_722 VPWR VGND sg13g2_decap_8
XFILLER_99_271 VPWR VGND sg13g2_fill_2
X_5358_ _8798_/D _5366_/A _5366_/B _5358_/C _5366_/D VPWR VGND sg13g2_nor4_1
X_8146_ _9073_/D _8164_/A1 _8077_/Y _8145_/Y VPWR VGND sg13g2_o21ai_1
XFILLER_101_221 VPWR VGND sg13g2_fill_2
X_8077_ _8077_/Y _8089_/A _9492_/Q _8092_/C _8095_/D VPWR VGND sg13g2_nand4_1
X_4309_ _7132_/C _7036_/B VPWR VGND sg13g2_inv_1
XFILLER_101_254 VPWR VGND sg13g2_decap_8
X_5289_ _5368_/C _5319_/A _9495_/Q VPWR VGND sg13g2_nand2_1
X_7028_ _7029_/B _7028_/A _7028_/B _7028_/C _7028_/D VPWR VGND sg13g2_nor4_1
XFILLER_83_650 VPWR VGND sg13g2_decap_4
X_8979_ _8979_/Q _9199_/CLK _8979_/D place2427/X VPWR VGND sg13g2_dfrbpq_1
XFILLER_15_205 VPWR VGND sg13g2_fill_1
XFILLER_28_588 VPWR VGND sg13g2_fill_1
X_9568__2822 _9568_/RESET_B VPWR VGND sg13g2_tiehi
XFILLER_70_333 VPWR VGND sg13g2_fill_1
XFILLER_15_227 VPWR VGND sg13g2_decap_4
XFILLER_43_569 VPWR VGND sg13g2_decap_8
Xclkbuf_3_0__f_clk_i clkbuf_3_0__f_clk_i/X clkbuf_0_clk_i/X VPWR VGND sg13g2_buf_8
XFILLER_90_58 VPWR VGND sg13g2_fill_1
XFILLER_24_783 VPWR VGND sg13g2_fill_2
XFILLER_11_455 VPWR VGND sg13g2_decap_8
XFILLER_23_96 VPWR VGND sg13g2_decap_4
XFILLER_99_89 VPWR VGND sg13g2_decap_8
XFILLER_3_0 VPWR VGND sg13g2_decap_8
XFILLER_105_571 VPWR VGND sg13g2_fill_2
XFILLER_105_560 VPWR VGND sg13g2_decap_8
XFILLER_3_687 VPWR VGND sg13g2_decap_8
XFILLER_2_186 VPWR VGND sg13g2_fill_1
XFILLER_65_127 VPWR VGND sg13g2_decap_8
XFILLER_74_672 VPWR VGND sg13g2_decap_4
XFILLER_0_56 VPWR VGND sg13g2_decap_8
XFILLER_73_193 VPWR VGND sg13g2_fill_2
XFILLER_73_182 VPWR VGND sg13g2_decap_8
XFILLER_61_333 VPWR VGND sg13g2_fill_1
XFILLER_61_322 VPWR VGND sg13g2_fill_1
XFILLER_61_377 VPWR VGND sg13g2_fill_1
XFILLER_9_21 VPWR VGND sg13g2_decap_8
XFILLER_15_750 VPWR VGND sg13g2_decap_8
XFILLER_119_107 VPWR VGND sg13g2_fill_1
X_4660_ _9647_/D _4660_/A _4666_/A VPWR VGND sg13g2_nor2_1
Xplace2316 _6901_/S _6877_/S VPWR VGND sg13g2_buf_1
Xplace2305 _5132_/B _5123_/B VPWR VGND sg13g2_buf_1
Xplace2338 _5238_/A _9870_/A VPWR VGND sg13g2_buf_1
X_4591_ _4592_/B _5628_/B _4591_/B _9707_/Q VPWR VGND sg13g2_nor3_1
Xplace2327 _4883_/A _4944_/A VPWR VGND sg13g2_buf_1
X_6330_ _9374_/D _6325_/Y _6328_/X _6329_/Y VPWR VGND sg13g2_a21oi_1
Xplace2349 _8086_/A _8401_/C VPWR VGND sg13g2_buf_1
XFILLER_50_2 VPWR VGND sg13g2_fill_1
XFILLER_6_470 VPWR VGND sg13g2_fill_1
X_6261_ _6262_/D _9233_/Q _6516_/C _6189_/C VPWR VGND sg13g2_a21oi_1
XFILLER_115_368 VPWR VGND sg13g2_decap_4
XFILLER_69_411 VPWR VGND sg13g2_decap_4
X_5212_ _5212_/Y _9869_/A _5205_/Y _5211_/Y VPWR VGND sg13g2_o21ai_1
Xhold3029 _6110_/B1 _9348_/Q VPWR VGND sg13g2_dlygate4sd3_1
Xhold3018 _6122_/B1 _9350_/Q VPWR VGND sg13g2_dlygate4sd3_1
X_6192_ _6192_/Y _6408_/B _6191_/Y _6189_/X _6438_/B _6451_/D VPWR VGND sg13g2_a221oi_1
Xhold3007 _8125_/A _9063_/Q VPWR VGND sg13g2_dlygate4sd3_1
X_8000_ _9010_/D _8489_/A2 _8017_/A _7999_/Y VPWR VGND sg13g2_o21ai_1
XFILLER_69_422 VPWR VGND sg13g2_fill_1
X_5143_ _8034_/D _8355_/C _9476_/Q VPWR VGND sg13g2_and2_1
XFILLER_36_0 VPWR VGND sg13g2_decap_4
XFILLER_111_563 VPWR VGND sg13g2_fill_2
X_5074_ _5074_/Y _7775_/C _7775_/A _7006_/C _5836_/C VPWR VGND sg13g2_nor4_1
XFILLER_56_105 VPWR VGND sg13g2_decap_4
X_9882_ _9882_/X _9882_/A VPWR VGND sg13g2_buf_1
X_8902_ _8902_/Q _9620_/CLK _8902_/D place2438/X VPWR VGND sg13g2_dfrbpq_1
XFILLER_37_330 VPWR VGND sg13g2_decap_8
X_8833_ _8833_/Q _9692_/CLK _8833_/D place2496/X VPWR VGND sg13g2_dfrbpq_1
XFILLER_25_547 VPWR VGND sg13g2_decap_8
X_5976_ _9327_/D _5978_/B _5974_/Y _5975_/Y VPWR VGND sg13g2_o21ai_1
XFILLER_80_664 VPWR VGND sg13g2_decap_8
X_8764_ _9870_/A _9252_/CLK _8764_/D place2400/X VPWR VGND sg13g2_dfrbpq_1
XFILLER_52_366 VPWR VGND sg13g2_fill_2
XFILLER_100_46 VPWR VGND sg13g2_decap_8
X_7715_ _7716_/D _9268_/Q _7551_/B _7771_/A2 _9881_/A _7714_/Y VPWR VGND sg13g2_a221oi_1
X_8695_ _8695_/Q _9630_/CLK _8695_/D fanout955/X VPWR VGND sg13g2_dfrbpq_1
X_4927_ _4927_/Y _4922_/Y _4926_/Y _4783_/B VPWR VGND sg13g2_a21oi_1
XFILLER_60_17 VPWR VGND sg13g2_fill_1
X_7646_ _7647_/D _9041_/Q _7544_/B _7645_/Y VPWR VGND sg13g2_o21ai_1
X_4858_ _4858_/Y _4791_/B _4768_/C _4856_/Y VPWR VGND sg13g2_o21ai_1
XFILLER_119_630 VPWR VGND sg13g2_decap_8
XFILLER_20_252 VPWR VGND sg13g2_decap_8
X_9316_ _9316_/Q _9410_/CLK _9316_/D place2396/X VPWR VGND sg13g2_dfrbpq_1
X_7577_ _7577_/Y _7577_/A _7812_/S VPWR VGND sg13g2_nor2_1
X_4789_ _4789_/Y _4842_/A _4791_/B VPWR VGND sg13g2_nor2_1
XFILLER_114_7 VPWR VGND sg13g2_fill_2
X_6528_ _6528_/Y _6528_/A _6523_/D VPWR VGND sg13g2_nor2b_1
XFILLER_4_418 VPWR VGND sg13g2_decap_8
X_6459_ _6459_/Y _6510_/B _9233_/Q _6459_/C _6516_/C VPWR VGND sg13g2_nand4_1
X_9247_ _9247_/Q _9251_/CLK _9247_/D place2479/X VPWR VGND sg13g2_dfrbpq_1
X_9178_ _9178_/Q clkload4/A _9178_/D place2482/X VPWR VGND sg13g2_dfrbpq_1
X_8129_ _8129_/Y _8129_/A _8129_/B VPWR VGND sg13g2_nand2_1
XFILLER_87_241 VPWR VGND sg13g2_fill_1
XFILLER_48_606 VPWR VGND sg13g2_fill_2
X_9492__2888 _9492_/RESET_B VPWR VGND sg13g2_tiehi
XFILLER_63_609 VPWR VGND sg13g2_decap_8
XFILLER_18_74 VPWR VGND sg13g2_decap_4
XFILLER_18_85 VPWR VGND sg13g2_decap_8
XFILLER_71_653 VPWR VGND sg13g2_fill_1
XFILLER_71_675 VPWR VGND sg13g2_decap_8
XFILLER_43_355 VPWR VGND sg13g2_fill_2
XFILLER_11_274 VPWR VGND sg13g2_decap_8
XFILLER_7_256 VPWR VGND sg13g2_decap_8
XFILLER_50_61 VPWR VGND sg13g2_decap_8
XFILLER_7_289 VPWR VGND sg13g2_decap_8
XFILLER_112_338 VPWR VGND sg13g2_decap_8
XFILLER_112_327 VPWR VGND sg13g2_fill_1
XFILLER_94_701 VPWR VGND sg13g2_fill_1
XFILLER_94_734 VPWR VGND sg13g2_decap_8
XFILLER_38_105 VPWR VGND sg13g2_decap_8
Xclkbuf_0_i_dmi_jtag.i_dmi_jtag_tap.i_dft_tck_mux.clk_o clkbuf_0_i_dmi_jtag.i_dmi_jtag_tap.i_dft_tck_mux.clk_o/X
+ i_dmi_jtag.i_dmi_jtag_tap.i_dft_tck_mux.i_mux/X VPWR VGND sg13g2_buf_8
XFILLER_47_661 VPWR VGND sg13g2_fill_1
X_5830_ _5830_/Y _5837_/A2 _9471_/Q VPWR VGND sg13g2_nand2b_1
X_5761_ _5761_/Y _5769_/B _9327_/Q VPWR VGND sg13g2_nand2_1
XFILLER_22_539 VPWR VGND sg13g2_decap_8
X_7500_ _8908_/D _7499_/Y _7576_/S _7479_/Y VPWR VGND sg13g2_a21oi_1
X_4712_ _4712_/X _4715_/A _4714_/B VPWR VGND sg13g2_or2_1
X_8480_ _8480_/Y _8490_/A _9245_/Q _8490_/C VPWR VGND sg13g2_nand3_1
X_7431_ _7433_/B _7431_/A _8747_/Q _8498_/B _7431_/D VPWR VGND sg13g2_nand4_1
X_5692_ _8599_/D _5692_/A VPWR VGND sg13g2_inv_1
X_4643_ _8741_/D _9554_/Q _4613_/Y _4642_/Y VPWR VGND sg13g2_a21o_1
Xplace2102 _7544_/B _7719_/B VPWR VGND sg13g2_buf_1
XFILLER_116_622 VPWR VGND sg13g2_decap_8
Xplace2146 _5175_/B _5098_/A VPWR VGND sg13g2_buf_1
Xplace2135 _5223_/B _5243_/B VPWR VGND sg13g2_buf_1
Xplace2113 _8068_/D _4560_/B VPWR VGND sg13g2_buf_1
Xplace2124 _6325_/A1 _6145_/B VPWR VGND sg13g2_buf_1
X_4574_ _9707_/D _4743_/A _4581_/A VPWR VGND sg13g2_and2_1
X_7362_ _7366_/A _7369_/C _7404_/B _9089_/Q VPWR VGND sg13g2_nor3_1
X_9101_ _9101_/Q clkload6/A _9101_/D place2434/X VPWR VGND sg13g2_dfrbpq_1
Xplace2168 _5525_/D _6541_/B VPWR VGND sg13g2_buf_1
X_6313_ _6313_/Y _6512_/A1 _6512_/A2 _6313_/B1 VPWR VGND sg13g2_a21oi_1
X_7293_ _7294_/D _9178_/Q _7815_/B _7489_/A VPWR VGND sg13g2_o21ai_1
Xplace2179 _7490_/C _7820_/C VPWR VGND sg13g2_buf_1
Xplace2157 _7485_/B _7815_/B VPWR VGND sg13g2_buf_1
X_9032_ _9032_/Q _9188_/CLK _9032_/D place2474/X VPWR VGND sg13g2_dfrbpq_1
X_6244_ _6244_/Y _6055_/A _6379_/A2 _6244_/B1 VPWR VGND sg13g2_a21oi_1
XFILLER_97_561 VPWR VGND sg13g2_decap_8
XFILLER_69_252 VPWR VGND sg13g2_fill_1
X_6175_ _9355_/D _9355_/Q _6253_/S _6174_/Y VPWR VGND sg13g2_a21o_1
X_5126_ _5126_/Y _5177_/A _5126_/B _5146_/D _6519_/D VPWR VGND sg13g2_nor4_1
XFILLER_85_723 VPWR VGND sg13g2_decap_8
XFILLER_57_425 VPWR VGND sg13g2_fill_1
XFILLER_29_105 VPWR VGND sg13g2_decap_8
XFILLER_29_116 VPWR VGND sg13g2_fill_1
XFILLER_111_393 VPWR VGND sg13g2_fill_1
X_5057_ _6519_/D _5057_/A _9410_/Q VPWR VGND sg13g2_nor2b_1
XFILLER_57_447 VPWR VGND sg13g2_fill_1
X_9865_ _9865_/X _9865_/A VPWR VGND sg13g2_buf_1
XFILLER_53_642 VPWR VGND sg13g2_fill_1
XFILLER_25_322 VPWR VGND sg13g2_decap_8
XFILLER_38_694 VPWR VGND sg13g2_fill_1
XFILLER_111_34 VPWR VGND sg13g2_fill_1
XFILLER_53_664 VPWR VGND sg13g2_fill_1
X_8816_ _8816_/Q _9692_/CLK _8816_/D place2492/X VPWR VGND sg13g2_dfrbpq_1
XFILLER_25_344 VPWR VGND sg13g2_decap_8
XFILLER_25_366 VPWR VGND sg13g2_decap_8
XFILLER_41_804 VPWR VGND sg13g2_fill_1
X_5959_ _5959_/Y _9487_/Q _5980_/A2 _5831_/X _5980_/B2 VPWR VGND sg13g2_a22oi_1
XFILLER_111_78 VPWR VGND sg13g2_fill_1
XFILLER_80_494 VPWR VGND sg13g2_decap_4
X_9477__2903 _9477_/RESET_B VPWR VGND sg13g2_tiehi
X_8747_ _8747_/Q _9254_/CLK _8747_/D place2456/X VPWR VGND sg13g2_dfrbpq_1
Xdelaybuf_3_clk_jtg delaybuf_4_clk_jtg/A delaybuf_3_clk_jtg/A VPWR VGND sg13g2_buf_8
X_8678_ _8678_/Q _8678_/CLK _8678_/D fanout944/X VPWR VGND sg13g2_dfrbpq_1
X_7629_ _7630_/D _9040_/Q _7767_/B VPWR VGND sg13g2_nor2_1
XFILLER_106_132 VPWR VGND sg13g2_decap_8
XFILLER_20_20 VPWR VGND sg13g2_decap_4
XFILLER_96_13 VPWR VGND sg13g2_decap_4
Xplace1990 _7301_/B _7787_/B VPWR VGND sg13g2_buf_1
XFILLER_0_410 VPWR VGND sg13g2_decap_8
XFILLER_96_57 VPWR VGND sg13g2_decap_8
XFILLER_0_498 VPWR VGND sg13g2_decap_8
XFILLER_76_767 VPWR VGND sg13g2_decap_8
XFILLER_91_726 VPWR VGND sg13g2_decap_8
XFILLER_91_759 VPWR VGND sg13g2_decap_8
XFILLER_44_620 VPWR VGND sg13g2_decap_4
XFILLER_31_303 VPWR VGND sg13g2_fill_1
XFILLER_8_521 VPWR VGND sg13g2_fill_2
XFILLER_77_7 VPWR VGND sg13g2_decap_8
Xinput2591 _5937_/B2 master_rdata_i[21] VPWR VGND sg13g2_buf_1
Xinput2580 _5921_/A master_rdata_i[11] VPWR VGND sg13g2_buf_1
XFILLER_8_565 VPWR VGND sg13g2_decap_8
XFILLER_113_647 VPWR VGND sg13g2_decap_4
XFILLER_79_583 VPWR VGND sg13g2_decap_8
XFILLER_94_542 VPWR VGND sg13g2_fill_1
XFILLER_67_778 VPWR VGND sg13g2_decap_8
XFILLER_67_756 VPWR VGND sg13g2_decap_4
X_7980_ _9000_/D _5354_/C _7979_/A _7979_/Y VPWR VGND sg13g2_o21ai_1
XFILLER_81_236 VPWR VGND sg13g2_decap_8
X_6931_ _6931_/Y _9698_/Q _6931_/B VPWR VGND sg13g2_nor2_1
X_9650_ _9650_/Q _9662_/CLK _9650_/D place2448/X VPWR VGND sg13g2_dfrbpq_1
X_6862_ _9597_/D _6861_/X _9597_/Q _6904_/S VPWR VGND sg13g2_mux2_1
XFILLER_50_601 VPWR VGND sg13g2_fill_1
XFILLER_23_804 VPWR VGND sg13g2_fill_1
XFILLER_34_130 VPWR VGND sg13g2_fill_1
X_9581_ _9581_/Q _9588_/CLK _9581_/D _9581_/RESET_B VPWR VGND sg13g2_dfrbpq_1
X_5813_ _9299_/D _5813_/A VPWR VGND sg13g2_inv_1
X_9596__2794 _9596_/RESET_B VPWR VGND sg13g2_tiehi
XFILLER_62_494 VPWR VGND sg13g2_decap_4
X_8601_ _8601_/Q _9708_/CLK _8601_/D fanout947/X VPWR VGND sg13g2_dfrbpq_1
XFILLER_34_163 VPWR VGND sg13g2_decap_8
X_8532_ _8533_/B _8540_/A _8532_/B _8532_/C _8532_/D VPWR VGND sg13g2_nand4_1
X_6793_ _6793_/Y _4693_/C _4691_/X _6793_/B1 VPWR VGND sg13g2_o21ai_1
X_5744_ _5744_/Y _5763_/B1 _5742_/Y _5743_/Y VPWR VGND sg13g2_a21oi_1
XFILLER_108_408 VPWR VGND sg13g2_decap_8
X_5675_ _5676_/A _8592_/Q _5677_/A2 _5677_/B1 _5675_/B2 VPWR VGND sg13g2_a22oi_1
X_8463_ _9236_/D _8488_/A _5350_/C _8462_/Y VPWR VGND sg13g2_o21ai_1
X_4626_ _6742_/D _9636_/Q _8709_/Q VPWR VGND sg13g2_nor2b_1
X_7414_ _7416_/B _7831_/C _7650_/C _8841_/Q VPWR VGND sg13g2_nand3_1
X_8394_ _9197_/D _5365_/C _8411_/A _8393_/Y VPWR VGND sg13g2_o21ai_1
X_7345_ _7348_/A _7351_/C _9119_/Q _7387_/C VPWR VGND sg13g2_nor3_1
XFILLER_89_303 VPWR VGND sg13g2_decap_8
X_4557_ _4557_/Y _4555_/Y _4556_/Y _7028_/A VPWR VGND sg13g2_a21oi_1
X_4488_ _4489_/B _4488_/A _4378_/B VPWR VGND sg13g2_nor2b_1
XFILLER_89_314 VPWR VGND sg13g2_fill_2
X_7276_ _7280_/B _7278_/C _8991_/Q _7295_/C VPWR VGND sg13g2_nor3_1
X_9015_ _9015_/Q clkload7/A _9015_/D place2457/X VPWR VGND sg13g2_dfrbpq_1
X_6227_ _6227_/Y _6133_/X _6459_/C _6248_/C _6226_/Y _6348_/D VPWR VGND sg13g2_a221oi_1
X_6158_ _6237_/B _6158_/A _9244_/Q _9243_/Q VPWR VGND sg13g2_nor3_1
XFILLER_111_190 VPWR VGND sg13g2_decap_8
X_5109_ _5347_/C _8399_/C _9474_/Q VPWR VGND sg13g2_nand2_1
XFILLER_73_704 VPWR VGND sg13g2_fill_2
X_6089_ _6176_/A _6348_/D _6171_/C VPWR VGND sg13g2_xor2_1
XFILLER_38_480 VPWR VGND sg13g2_decap_8
XFILLER_40_100 VPWR VGND sg13g2_fill_2
XFILLER_15_97 VPWR VGND sg13g2_decap_8
XFILLER_107_452 VPWR VGND sg13g2_decap_4
XFILLER_103_0 VPWR VGND sg13g2_decap_8
XFILLER_0_251 VPWR VGND sg13g2_decap_4
XFILLER_1_774 VPWR VGND sg13g2_decap_4
XFILLER_102_190 VPWR VGND sg13g2_decap_8
Xhold3190 _4581_/B _9703_/Q VPWR VGND sg13g2_dlygate4sd3_1
XFILLER_76_575 VPWR VGND sg13g2_decap_4
XFILLER_29_480 VPWR VGND sg13g2_fill_2
XFILLER_29_491 VPWR VGND sg13g2_decap_8
XFILLER_48_299 VPWR VGND sg13g2_fill_1
XFILLER_91_578 VPWR VGND sg13g2_fill_1
XFILLER_16_163 VPWR VGND sg13g2_decap_8
XFILLER_32_623 VPWR VGND sg13g2_fill_1
XFILLER_31_111 VPWR VGND sg13g2_fill_1
XFILLER_32_678 VPWR VGND sg13g2_fill_1
X_5460_ _8688_/D _5460_/A _5468_/B_N VPWR VGND sg13g2_nor2b_1
XFILLER_8_362 VPWR VGND sg13g2_decap_8
XFILLER_8_351 VPWR VGND sg13g2_fill_2
Xoutput2714 master_wdata_o[24] _5773_/X VPWR VGND sg13g2_buf_1
Xoutput2703 master_wdata_o[14] _5737_/Y VPWR VGND sg13g2_buf_1
X_4411_ _9693_/D _4411_/A _4590_/C VPWR VGND sg13g2_nand2_1
XFILLER_99_612 VPWR VGND sg13g2_decap_4
Xoutput2725 master_wdata_o[5] _5714_/X VPWR VGND sg13g2_buf_1
Xoutput2747 slave_rdata_o[23] _4967_/Y VPWR VGND sg13g2_buf_1
X_5391_ _5414_/A _6090_/A _5391_/B _8749_/Q VPWR VGND sg13g2_nand3_1
Xoutput2736 slave_rdata_o[13] _4892_/Y VPWR VGND sg13g2_buf_1
X_4342_ _6692_/D _9660_/Q _9659_/Q _9657_/Q VPWR VGND sg13g2_nor3_1
X_7130_ _7130_/Y _5374_/C _7130_/A2 _7129_/Y VPWR VGND sg13g2_o21ai_1
Xoutput2758 slave_rdata_o[4] _4803_/Y VPWR VGND sg13g2_buf_1
XFILLER_4_590 VPWR VGND sg13g2_decap_8
X_7061_ _7085_/S _7182_/D _6962_/Y _6964_/Y VPWR VGND sg13g2_o21ai_1
XFILLER_113_477 VPWR VGND sg13g2_decap_4
XFILLER_101_639 VPWR VGND sg13g2_fill_2
XFILLER_98_166 VPWR VGND sg13g2_fill_2
X_6012_ _6013_/B _9343_/Q _4455_/B _4518_/Y VPWR VGND sg13g2_o21ai_1
.ends
